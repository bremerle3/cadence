simulator( 'spectre )
design(	 "/home/warehouse/lbremer/cadence/simulation/closed_loop_add/spectre/schematic/netlist/netlist")
resultsDir( "/home/warehouse/lbremer/cadence/simulation/closed_loop_add/spectre/schematic" )
modelFile(
    '("/project/linuxlab/cadence/CDK/ncsu/models/spectre/nom/ami06N.m" "")
    '("/project/linuxlab/cadence/CDK/ncsu/models/spectre/nom/ami06P.m" "")
)
analysis('tran ?stop "1.8u"  )
envOption(
	'analysisOrder  list("tran")
)
temp( 27 )
run()
selectResult( 'tran )
plot(getData("/S1") getData("/S0") getData("/F1") getData("/F2") getData("/AC<0>") getData("/AC<1>") getData("/AC<2>") getData("/AC<3>") )
modelFile(
    '("/project/linuxlab/cadence/CDK/ncsu/models/spectre/nom/ami06N.m" "")
    '("/project/linuxlab/cadence/CDK/ncsu/models/spectre/nom/ami06P.m" "")
)
run()
selectResult( 'tran )
plot(getData("/IN<0>") getData("/IN<1>") getData("/IN<2>") getData("/IN<3>") getData("/AC<0>") getData("/AC<1>") getData("/AC<2>") getData("/AC<3>") getData("/F2") getData("/F1") getData("/S0") getData("/S1") )
modelFile(
    '("/project/linuxlab/cadence/CDK/ncsu/models/spectre/nom/ami06N.m" "")
    '("/project/linuxlab/cadence/CDK/ncsu/models/spectre/nom/ami06P.m" "")
)
run()
selectResult( 'tran )
plot(getData("/AC<0>") getData("/AC<1>") getData("/AC<2>") getData("/AC<3>") getData("/F2") getData("/F1") getData("/S0") getData("/S1") getData("/IN<0>") getData("/IN<1>") getData("/IN<2>") getData("/IN<3>") )
modelFile(
    '("/project/linuxlab/cadence/CDK/ncsu/models/spectre/nom/ami06N.m" "")
    '("/project/linuxlab/cadence/CDK/ncsu/models/spectre/nom/ami06P.m" "")
)
run()
selectResult( 'tran )
plot(getData("/I2/MUX3<0>") getData("/I2/MUX2<0>") getData("/I2/MUX1<0>") getData("/I2/MUX0<0>") getData("/AC<0>") getData("/AC<1>") getData("/AC<2>") getData("/AC<3>") getData("/F2") getData("/F1") getData("/S0") getData("/S1") getData("/IN<0>") getData("/IN<1>") getData("/IN<2>") getData("/IN<3>") )
modelFile(
    '("/project/linuxlab/cadence/CDK/ncsu/models/spectre/nom/ami06N.m" "")
    '("/project/linuxlab/cadence/CDK/ncsu/models/spectre/nom/ami06P.m" "")
)
run()
selectResult( 'tran )
plot(getData("/AC<0>") getData("/AC<1>") getData("/AC<2>") getData("/AC<3>") getData("/F2") getData("/F1") getData("/S0") getData("/S1") getData("/IN<0>") getData("/IN<1>") getData("/IN<2>") getData("/IN<3>") getData("/I2/MUX0<0>") getData("/I2/MUX1<0>") getData("/I2/MUX2<0>") getData("/I2/MUX3<0>") )
modelFile(
    '("/project/linuxlab/cadence/CDK/ncsu/models/spectre/nom/ami06N.m" "")
    '("/project/linuxlab/cadence/CDK/ncsu/models/spectre/nom/ami06P.m" "")
)
run()
selectResult( 'tran )
plot(getData("/AC<0>") getData("/AC<1>") getData("/AC<2>") getData("/AC<3>") getData("/F2") getData("/F1") getData("/S0") getData("/S1") getData("/IN<0>") getData("/IN<1>") getData("/IN<2>") getData("/IN<3>") getData("/I2/MUX0<0>") getData("/I2/MUX1<0>") getData("/I2/MUX2<0>") getData("/I2/MUX3<0>") )
modelFile(
    '("/project/linuxlab/cadence/CDK/ncsu/models/spectre/nom/ami06N.m" "")
    '("/project/linuxlab/cadence/CDK/ncsu/models/spectre/nom/ami06P.m" "")
)
run()
selectResult( 'tran )
plot(getData("/AC<0>") getData("/AC<1>") getData("/AC<2>") getData("/AC<3>") getData("/F2") getData("/F1") getData("/S0") getData("/S1") getData("/IN<0>") getData("/IN<1>") getData("/IN<2>") getData("/IN<3>") getData("/I2/MUX0<0>") getData("/I2/MUX1<0>") getData("/I2/MUX2<0>") getData("/I2/MUX3<0>") )
