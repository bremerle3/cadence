simulator( 'spectre )
design(	 "/home/warehouse/lbremer/cadence/simulation/clear_extracted_test/spectre/schematic/netlist/netlist")
resultsDir( "/home/warehouse/lbremer/cadence/simulation/clear_extracted_test/spectre/schematic" )
modelFile(
    '("/project/linuxlab/cadence/CDK/ncsu/models/spectre/nom/ami06N.m" "")
    '("/project/linuxlab/cadence/CDK/ncsu/models/spectre/nom/ami06P.m" "")
)
temp( 27 )
run()
modelFile(
    '("/project/linuxlab/cadence/CDK/ncsu/models/spectre/nom/ami06N.m" "")
    '("/project/linuxlab/cadence/CDK/ncsu/models/spectre/nom/ami06P.m" "")
)
run()
modelFile(
    '("/project/linuxlab/cadence/CDK/ncsu/models/spectre/nom/ami06N.m" "")
    '("/project/linuxlab/cadence/CDK/ncsu/models/spectre/nom/ami06P.m" "")
)
run()
modelFile(
    '("/project/linuxlab/cadence/CDK/ncsu/models/spectre/nom/ami06N.m" "")
    '("/project/linuxlab/cadence/CDK/ncsu/models/spectre/nom/ami06P.m" "")
)
analysis('tran ?stop "800n"  )
envOption(
	'analysisOrder  list("tran")
)
run()
selectResult( 'tran )
plot(getData("/F2") getData("/F1") getData("/FF_Out") getData("/FF_in") getData("/Input") getData("/net12") getData("/net11") getData("/net10") getData("/net1") )
modelFile(
    '("/project/linuxlab/cadence/CDK/ncsu/models/spectre/nom/ami06N.m" "")
    '("/project/linuxlab/cadence/CDK/ncsu/models/spectre/nom/ami06P.m" "")
)
run()
selectResult( 'tran )
plot(getData("/S0B") getData("/S0") getData("/S1B") getData("/S1") getData("/Input") getData("/FF_in") getData("/FF_Out") getData("/F1") getData("/F2") )
modelFile(
    '("/project/linuxlab/cadence/CDK/ncsu/models/spectre/nom/ami06N.m" "")
    '("/project/linuxlab/cadence/CDK/ncsu/models/spectre/nom/ami06P.m" "")
)
run()
selectResult( 'tran )
plot(getData("/Input") getData("/FF_in") getData("/FF_Out") getData("/F1") getData("/F2") getData("/S1") getData("/S1B") getData("/S0") getData("/S0B") )
modelFile(
    '("/project/linuxlab/cadence/CDK/ncsu/models/spectre/nom/ami06N.m" "")
    '("/project/linuxlab/cadence/CDK/ncsu/models/spectre/nom/ami06P.m" "")
)
run()
selectResult( 'tran )
plot(getData("/Input") getData("/FF_in") getData("/FF_Out") getData("/F1") getData("/F2") getData("/S1") getData("/S1B") getData("/S0") getData("/S0B") )
modelFile(
    '("/project/linuxlab/cadence/CDK/ncsu/models/spectre/nom/ami06N.m" "")
    '("/project/linuxlab/cadence/CDK/ncsu/models/spectre/nom/ami06P.m" "")
)
run()
selectResult( 'tran )
plot(getData("/Input") getData("/FF_in") getData("/FF_Out") getData("/F1") getData("/F2") getData("/S1") getData("/S1B") getData("/S0") getData("/S0B") )
modelFile(
    '("/project/linuxlab/cadence/CDK/ncsu/models/spectre/nom/ami06N.m" "")
    '("/project/linuxlab/cadence/CDK/ncsu/models/spectre/nom/ami06P.m" "")
)
run()
selectResult( 'tran )
plot(getData("/Input") getData("/FF_in") getData("/FF_Out") getData("/F1") getData("/F2") getData("/S1") getData("/S1B") getData("/S0") getData("/S0B") )
modelFile(
    '("/project/linuxlab/cadence/CDK/ncsu/models/spectre/nom/ami06N.m" "")
    '("/project/linuxlab/cadence/CDK/ncsu/models/spectre/nom/ami06P.m" "")
)
run()
selectResult( 'tran )
plot(getData("/Input") getData("/FF_in") getData("/FF_Out") getData("/F1") getData("/F2") getData("/S1") getData("/S1B") getData("/S0") getData("/S0B") )
modelFile(
    '("/project/linuxlab/cadence/CDK/ncsu/models/spectre/nom/ami06N.m" "")
    '("/project/linuxlab/cadence/CDK/ncsu/models/spectre/nom/ami06P.m" "")
)
run()
selectResult( 'tran )
plot(getData("/Input") getData("/FF_in") getData("/FF_Out") getData("/F1") getData("/F2") getData("/S1") getData("/S1B") getData("/S0") getData("/S0B") )
modelFile(
    '("/project/linuxlab/cadence/CDK/ncsu/models/spectre/nom/ami06N.m" "")
    '("/project/linuxlab/cadence/CDK/ncsu/models/spectre/nom/ami06P.m" "")
)
run()
selectResult( 'tran )
plot(getData("/Input") getData("/FF_in") getData("/FF_Out") getData("/F1") getData("/F2") getData("/S1") getData("/S1B") getData("/S0") getData("/S0B") )
modelFile(
    '("/project/linuxlab/cadence/CDK/ncsu/models/spectre/nom/ami06N.m" "")
    '("/project/linuxlab/cadence/CDK/ncsu/models/spectre/nom/ami06P.m" "")
)
run()
selectResult( 'tran )
plot(getData("/Input") getData("/FF_in") getData("/FF_Out") getData("/F1") getData("/F2") getData("/S1") getData("/S1B") getData("/S0") getData("/S0B") )
