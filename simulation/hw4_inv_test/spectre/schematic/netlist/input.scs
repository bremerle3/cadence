// Design: 563_final/hw4_inv_test
simulator lang=spectre
global 0 vdd!
include "/project/linuxlab/cadence/CDK/ncsu/models/spectre/nom/ami06N.m"
include "/project/linuxlab/cadence/CDK/ncsu/models/spectre/nom/ami06P.m"

// 563_final/hw4_inv/schematic
subckt hw4_inv Vin Vout
    N0 (Vout Vin 0 0) ami06N w=1.95u l=900n m=1 region=sat
    P0 (Vout Vin vdd! vdd!) ami06P w=1.95u l=900n m=1 region=sat
ends hw4_inv

// 563_final/hw4_inv_test/schematic
I0 (net2 net1) hw4_inv
V1 (net2 0) vsource type=pulse val0=0 val1=0
V0 (vdd! 0) vsource type=pulse val0=0 val1=5 delay=100.0p
C0 (net1 0) capacitor c=100f m=1
simulatorOptions options temp=27
tran tran stop=100n
