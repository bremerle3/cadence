// Design: cse562/poly
simulator lang=spectre
global 0 vdd!
include "/project/linuxlab/cadence/CDK/ncsu/models/spectre/nom/ami06N.m"
include "/project/linuxlab/cadence/CDK/ncsu/models/spectre/nom/ami06P.m"

// cse562/i_squared/schematic
subckt i_squared I_In I_Out Ib_In
    N1 (I_Out I_Out 0 0) ami06N w=900n l=600n m=1 region=sat
    N0 (net15 Ib_In 0 0) ami06N w=900n l=600n m=1 region=sat
    N4 (net7 net7 net10 0) ami06N w=900n l=600n m=1 region=sat
    N5 (net10 net10 0 0) ami06N w=900n l=600n m=1 region=sat
    N6 (vdd! net7 net15 0) ami06N w=900n l=600n m=1 region=sat
    N7 (vdd! net15 I_Out 0) ami06N w=900n l=600n m=1 region=sat
    P0 (net7 I_In vdd! vdd!) ami06P w=900n l=600n m=1 region=sat
ends i_squared

// cse562/poly/schematic
I0 (vdd! net06 net1) i_squared
P1 (0 net06 vdd! vdd!) ami06P w=900n l=600n m=1 region=sat
P0 (net3 net3 vdd! vdd!) ami06P w=900n l=600n m=1 region=sat
N0 (net1 net1 0 0) ami06N w=900n l=600n m=1 region=sat
V2 (vdd! 0) vsource type=dc dc=3
I5 (net3 0) isource type=dc m=1
I4 (vdd! net1) isource type=dc dc=1n m=1
simulatorOptions options temp=27
dcOp dc
dc dc dev=I5 param=dc start=0 stop=5n
save I5:sink N0:d P1:d
