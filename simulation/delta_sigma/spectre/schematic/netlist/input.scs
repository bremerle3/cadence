// Design: cse562/delta_sigma
simulator lang=spectre
global 0 vdd!
parameters nW=900n nL=600n pW=900n pL=600n I_0=100n
include "/project/linuxlab/cadence/CDK/ncsu/models/spectre/nom/ami06N.m"
include "/project/linuxlab/cadence/CDK/ncsu/models/spectre/nom/ami06P.m"

// cse562/new_op_amp/schematic
subckt new_op_amp Vin\+ Vin\- Vout
    N2 (Vout net14 0 0) ami06N w=nW l=nL m=1 region=sat
    N1 (net14 net10 0 0) ami06N w=nW l=nL m=1 region=sat
    N0 (net10 net10 0 0) ami06N w=nW l=nL m=1 region=sat
    P4 (Vout net7 vdd! vdd!) ami06P w=pW l=pL m=1 region=sat
    P3 (net14 Vin\+ net12 net12) ami06P w=pW l=pL m=1 region=sat
    P2 (net10 Vin\- net12 net12) ami06P w=pW l=pL m=1 region=sat
    P1 (net12 net7 vdd! vdd!) ami06P w=pW l=pL m=1 region=sat
    P0 (net7 net7 vdd! vdd!) ami06P w=pW l=pL m=1 region=sat
    C0 (net14 Vout) capacitor c=100.0f m=1
    I2 (net7 0) isource type=dc dc=200n m=1
ends new_op_amp

// cse562/comparator/schematic
subckt comparator V\+ V\- Vout
    I27 (vdd! net2) isource type=dc dc=200n m=1
    N15 (net5 net2 net9 net9) ami06N w=nW l=nL m=1 region=sat
    N14 (net2 net2 net1 net1) ami06N w=nW l=nL m=1 region=sat
    N13 (net9 net1 0 0) ami06N w=nW l=nL m=1 region=sat
    N12 (net1 net1 0 0) ami06N w=nW l=nL m=1 region=sat
    N17 (net3 V\- net5 net5) ami06N w=nW l=nL m=1 region=sat
    N1 (net15 V\+ net5 net5) ami06N w=nW l=nL m=1 region=sat
    N2 (Vout net15 0 0) ami06N w=nW l=nL m=1 region=sat
    P4 (net15 net3 vdd! vdd!) ami06P w=pW l=pL m=1 region=sat
    P2 (net3 net3 vdd! vdd!) ami06P w=pW l=pL m=1 region=sat
    P5 (Vout net15 vdd! vdd!) ami06P w=pW l=pL m=1 region=sat
ends comparator

// cse562/true_ff/schematic
subckt true_ff CLK D Q
    N1 (net3 D 0 0) ami06N w=nW l=nL m=1 region=sat
    N6 (Q net7 0 0) ami06N w=nW l=nL m=1 region=sat
    N5 (net19 net5 0 0) ami06N w=nW l=nL m=1 region=sat
    N4 (net7 CLK net19 net19) ami06N w=nW l=nL m=1 region=sat
    N2 (net15 CLK 0 0) ami06N w=nW l=nL m=1 region=sat
    N3 (net5 net3 net15 net15) ami06N w=nW l=nL m=1 region=sat
    P4 (net3 CLK net10 net10) ami06P w=pW l=pL m=1 region=sat
    P1 (net10 D vdd! vdd!) ami06P w=pW l=pL m=1 region=sat
    P9 (Q net7 vdd! vdd!) ami06P w=pW l=pL m=1 region=sat
    P7 (net7 net5 vdd! vdd!) ami06P w=pW l=pL m=1 region=sat
    P5 (net5 CLK vdd! vdd!) ami06P w=pW l=pL m=1 region=sat
ends true_ff

// cse562/delta_sigma/schematic
P14 (net079 net028 vdd! vdd!) ami06P w=pW l=pL m=1 region=sat
P13 (net028 net01 vdd! vdd!) ami06P w=pW l=pL m=1 region=sat
P11 (net08 net023 net050 net050) ami06P w=pW l=pL m=1 region=sat
P12 (net023 net021 vdd! vdd!) ami06P w=pW l=pL m=1 region=sat
P10 (net02 net02 vdd! vdd!) ami06P w=pW l=pL m=1 region=sat
P3 (net022 net02 vdd! vdd!) ami06P w=pW l=pL m=1 region=sat
P2 (net045 net045 net02 net02) ami06P w=pW l=pL m=1 region=sat
P1 (net050 net045 net022 net022) ami06P w=pW l=pL m=1 region=sat
P0 (net050 net063 net05 net05) ami06P w=pW l=pL m=1 region=sat
P9 (net9 net079 net050 net050) ami06P w=pW l=pL m=1 region=sat
P8 (net063 net079 vdd! vdd!) ami06P w=pW l=pL m=1 region=sat
P4 (net6 net6 vdd! vdd!) ami06P w=pW l=pL m=1 region=sat
P5 (net5 net5 net6 net6) ami06P w=pW l=pL m=1 region=sat
P6 (net19 net6 vdd! vdd!) ami06P w=pW l=pL m=1 region=sat
P7 (net05 net5 net19 net19) ami06P w=pW l=pL m=1 region=sat
N10 (net079 net028 0 0) ami06N w=nW l=nL m=1 region=sat
N9 (net028 net01 0 0) ami06N w=nW l=nL m=1 region=sat
N5 (net050 net021 net08 net08) ami06N w=nW l=nL m=1 region=sat
N6 (net023 net021 0 0) ami06N w=nW l=nL m=1 region=sat
N4 (net05 net079 net050 net050) ami06N w=nW l=nL m=1 region=sat
N0 (net2 net2 net1 net1) ami06N w=900n l=600n m=1 region=sat
N8 (net050 net063 net9 net9) ami06N w=nW l=nL m=1 region=sat
N2 (net9 net2 net12 net12) ami06N w=900n l=600n m=1 region=sat
N1 (net1 net1 0 0) ami06N w=900n l=600n m=1 region=sat
N7 (net063 net079 0 0) ami06N w=nW l=nL m=1 region=sat
N3 (net12 net1 0 0) ami06N w=900n l=600n m=1 region=sat
V1 (net034 0) vsource type=dc dc=500.0m
V0 (vdd! 0) vsource type=dc dc=3
I16 (net5 0) isource type=dc dc=I_0 m=1
I0 (vdd! net2) isource type=dc dc=I_0 m=1
I61 (0 net050 net08) new_op_amp
C0 (net050 net08) capacitor c=20p m=1
I55 (net08 net034 net030) comparator
V2 (net021 0) vsource type=pulse val0=0 val1=5 period=100u rise=2p fall=2p width=200n
V3 (net033 0) vsource type=pulse val0=0 val1=5 period=125n rise=2p fall=2p width=62.5n
I54 (net045 0) isource type=pwl m=1 wave=[ 900n 0 100u 100n ]
I56 (net033 net030 net01) true_ff
simulatorOptions options temp=27
tran tran stop=20000n
