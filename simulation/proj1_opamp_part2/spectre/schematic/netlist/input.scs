// Design: cse562/proj1_opamp_part2
simulator lang=spectre
global 0 vdd!
include "/project/linuxlab/cadence/CDK/ncsu/models/spectre/nom/ami06N.m"
include "/project/linuxlab/cadence/CDK/ncsu/models/spectre/nom/ami06P.m"

// cse562/proj1_opamp/schematic
subckt proj1_opamp Vin\+ Vin\- Vout
    P4 (net9 Vin\+ net12 vdd!) ami06P w=100.05u l=3u m=1 region=sat
    P3 (net8 Vin\- net9 vdd!) ami06P w=100.05u l=3u m=1 region=sat
    P2 (net9 net7 vdd! vdd!) ami06P w=100.05u l=3u m=1 region=sat
    P1 (Vout net7 vdd! vdd!) ami06P w=100.05u l=3u m=1 region=sat
    P0 (vdd! net7 net14 vdd!) ami06P w=100.05u l=3u m=1 region=sat
    N2 (Vout net12 0 0) ami06N w=100.05u l=3u m=1 region=sat
    N1 (net12 net8 0 0) ami06N w=100.05u l=3u m=1 region=sat
    N0 (0 net8 net8 0) ami06N w=100.05u l=3u m=1 region=sat
    I17 (net14 0) isource type=dc dc=1nA m=1
    C0 (Vout net12) capacitor c=10p m=1
ends proj1_opamp

// cse562/proj1_opamp_part2/schematic
I0 (net03 net2 net2) proj1_opamp
V0 (vdd! 0) vsource type=dc dc=3
V2 (net03 0) vsource type=pulse val0=1.45 val1=1.55 period=2.5u
simulatorOptions options temp=27
tran tran stop=5u
save V0:p V0:p
