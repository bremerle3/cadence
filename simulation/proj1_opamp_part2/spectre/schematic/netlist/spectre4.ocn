simulator( 'spectre )
design(	 "/home/warehouse/lbremer/cadence/simulation/proj1_opamp_part2/spectre/schematic/netlist/netlist")
resultsDir( "/home/warehouse/lbremer/cadence/simulation/proj1_opamp_part2/spectre/schematic" )
modelFile(
    '("/project/linuxlab/cadence/CDK/ncsu/models/spectre/nom/ami06N.m" "")
    '("/project/linuxlab/cadence/CDK/ncsu/models/spectre/nom/ami06P.m" "")
)
analysis('tran ?stop "20n"  )
envOption(
	'analysisOrder  list("tran")
)
temp( 27 )
run()
selectResult( 'tran )
plot(getData("/net4") getData("/net2") )
modelFile(
    '("/project/linuxlab/cadence/CDK/ncsu/models/spectre/nom/ami06N.m" "")
    '("/project/linuxlab/cadence/CDK/ncsu/models/spectre/nom/ami06P.m" "")
)
run()
selectResult( 'tran )
plot(getData("/net2") getData("/net4") )
modelFile(
    '("/project/linuxlab/cadence/CDK/ncsu/models/spectre/nom/ami06N.m" "")
    '("/project/linuxlab/cadence/CDK/ncsu/models/spectre/nom/ami06P.m" "")
)
save( 'i "/V0/MINUS" "/V0/PLUS" )
run()
selectResult( 'tran )
plot(getData("/net2") getData("/net4") getData("/V0/MINUS") getData("/V0/PLUS") )
modelFile(
    '("/project/linuxlab/cadence/CDK/ncsu/models/spectre/nom/ami06N.m" "")
    '("/project/linuxlab/cadence/CDK/ncsu/models/spectre/nom/ami06P.m" "")
)
run()
selectResult( 'tran )
plot(getData("/net2") getData("/net4") getData("/V0/MINUS") getData("/V0/PLUS") )
modelFile(
    '("/project/linuxlab/cadence/CDK/ncsu/models/spectre/nom/ami06N.m" "")
    '("/project/linuxlab/cadence/CDK/ncsu/models/spectre/nom/ami06P.m" "")
)
run()
selectResult( 'tran )
plot(getData("/net2") getData("/net4") )
modelFile(
    '("/project/linuxlab/cadence/CDK/ncsu/models/spectre/nom/ami06N.m" "")
    '("/project/linuxlab/cadence/CDK/ncsu/models/spectre/nom/ami06P.m" "")
)
analysis('tran ?stop "2n"  )
run()
selectResult( 'tran )
plot(getData("/net2") getData("/net4") )
modelFile(
    '("/project/linuxlab/cadence/CDK/ncsu/models/spectre/nom/ami06N.m" "")
    '("/project/linuxlab/cadence/CDK/ncsu/models/spectre/nom/ami06P.m" "")
)
run()
selectResult( 'tran )
plot(getData("/net2") getData("/net4") )
modelFile(
    '("/project/linuxlab/cadence/CDK/ncsu/models/spectre/nom/ami06N.m" "")
    '("/project/linuxlab/cadence/CDK/ncsu/models/spectre/nom/ami06P.m" "")
)
run()
selectResult( 'tran )
plot(getData("/net2") getData("/net4") )
modelFile(
    '("/project/linuxlab/cadence/CDK/ncsu/models/spectre/nom/ami06N.m" "")
    '("/project/linuxlab/cadence/CDK/ncsu/models/spectre/nom/ami06P.m" "")
)
run()
selectResult( 'tran )
plot(getData("/net2") getData("/net4") )
modelFile(
    '("/project/linuxlab/cadence/CDK/ncsu/models/spectre/nom/ami06N.m" "")
    '("/project/linuxlab/cadence/CDK/ncsu/models/spectre/nom/ami06P.m" "")
)
analysis('tran ?stop "20n"  )
run()
selectResult( 'tran )
plot(getData("/net2") getData("/net4") )
modelFile(
    '("/project/linuxlab/cadence/CDK/ncsu/models/spectre/nom/ami06N.m" "")
    '("/project/linuxlab/cadence/CDK/ncsu/models/spectre/nom/ami06P.m" "")
)
run()
selectResult( 'tran )
plot(getData("/net2") getData("/net4") )
modelFile(
    '("/project/linuxlab/cadence/CDK/ncsu/models/spectre/nom/ami06N.m" "")
    '("/project/linuxlab/cadence/CDK/ncsu/models/spectre/nom/ami06P.m" "")
)
run()
selectResult( 'tran )
plot(getData("/net2") getData("/net4") )
modelFile(
    '("/project/linuxlab/cadence/CDK/ncsu/models/spectre/nom/ami06N.m" "")
    '("/project/linuxlab/cadence/CDK/ncsu/models/spectre/nom/ami06P.m" "")
)
run()
selectResult( 'tran )
plot(getData("/net2") getData("/net4") )
modelFile(
    '("/project/linuxlab/cadence/CDK/ncsu/models/spectre/nom/ami06N.m" "")
    '("/project/linuxlab/cadence/CDK/ncsu/models/spectre/nom/ami06P.m" "")
)
run()
selectResult( 'tran )
plot(getData("/net2") )
modelFile(
    '("/project/linuxlab/cadence/CDK/ncsu/models/spectre/nom/ami06N.m" "")
    '("/project/linuxlab/cadence/CDK/ncsu/models/spectre/nom/ami06P.m" "")
)
run()
selectResult( 'tran )
plot(getData("/net2") )
modelFile(
    '("/project/linuxlab/cadence/CDK/ncsu/models/spectre/nom/ami06N.m" "")
    '("/project/linuxlab/cadence/CDK/ncsu/models/spectre/nom/ami06P.m" "")
)
run()
selectResult( 'tran )
plot(getData("/net2") )
modelFile(
    '("/project/linuxlab/cadence/CDK/ncsu/models/spectre/nom/ami06N.m" "")
    '("/project/linuxlab/cadence/CDK/ncsu/models/spectre/nom/ami06P.m" "")
)
run()
selectResult( 'tran )
plot(getData("/net2") )
modelFile(
    '("/project/linuxlab/cadence/CDK/ncsu/models/spectre/nom/ami06N.m" "")
    '("/project/linuxlab/cadence/CDK/ncsu/models/spectre/nom/ami06P.m" "")
)
run()
selectResult( 'tran )
plot(getData("/net2") )
modelFile(
    '("/project/linuxlab/cadence/CDK/ncsu/models/spectre/nom/ami06N.m" "")
    '("/project/linuxlab/cadence/CDK/ncsu/models/spectre/nom/ami06P.m" "")
)
run()
selectResult( 'tran )
plot(getData("/net2") )
modelFile(
    '("/project/linuxlab/cadence/CDK/ncsu/models/spectre/nom/ami06N.m" "")
    '("/project/linuxlab/cadence/CDK/ncsu/models/spectre/nom/ami06P.m" "")
)
run()
selectResult( 'tran )
plot(getData("/net2") )
modelFile(
    '("/project/linuxlab/cadence/CDK/ncsu/models/spectre/nom/ami06N.m" "")
    '("/project/linuxlab/cadence/CDK/ncsu/models/spectre/nom/ami06P.m" "")
)
run()
selectResult( 'tran )
plot(getData("/net2") )
modelFile(
    '("/project/linuxlab/cadence/CDK/ncsu/models/spectre/nom/ami06N.m" "")
    '("/project/linuxlab/cadence/CDK/ncsu/models/spectre/nom/ami06P.m" "")
)
analysis('tran ?stop "2000n"  )
run()
selectResult( 'tran )
plot(getData("/net2") )
modelFile(
    '("/project/linuxlab/cadence/CDK/ncsu/models/spectre/nom/ami06N.m" "")
    '("/project/linuxlab/cadence/CDK/ncsu/models/spectre/nom/ami06P.m" "")
)
run()
selectResult( 'tran )
plot(getData("/net2") )
modelFile(
    '("/project/linuxlab/cadence/CDK/ncsu/models/spectre/nom/ami06N.m" "")
    '("/project/linuxlab/cadence/CDK/ncsu/models/spectre/nom/ami06P.m" "")
)
run()
selectResult( 'tran )
plot(getData("/net2") getData("/net4") )
modelFile(
    '("/project/linuxlab/cadence/CDK/ncsu/models/spectre/nom/ami06N.m" "")
    '("/project/linuxlab/cadence/CDK/ncsu/models/spectre/nom/ami06P.m" "")
)
run()
selectResult( 'tran )
plot(getData("/net2") )
modelFile(
    '("/project/linuxlab/cadence/CDK/ncsu/models/spectre/nom/ami06N.m" "")
    '("/project/linuxlab/cadence/CDK/ncsu/models/spectre/nom/ami06P.m" "")
)
run()
selectResult( 'tran )
plot(getData("/net2") )
modelFile(
    '("/project/linuxlab/cadence/CDK/ncsu/models/spectre/nom/ami06N.m" "")
    '("/project/linuxlab/cadence/CDK/ncsu/models/spectre/nom/ami06P.m" "")
)
analysis('tran ?stop "400n"  )
run()
selectResult( 'tran )
plot(getData("/net2") )
modelFile(
    '("/project/linuxlab/cadence/CDK/ncsu/models/spectre/nom/ami06N.m" "")
    '("/project/linuxlab/cadence/CDK/ncsu/models/spectre/nom/ami06P.m" "")
)
run()
selectResult( 'tran )
plot(getData("/net2") )
modelFile(
    '("/project/linuxlab/cadence/CDK/ncsu/models/spectre/nom/ami06N.m" "")
    '("/project/linuxlab/cadence/CDK/ncsu/models/spectre/nom/ami06P.m" "")
)
run()
selectResult( 'tran )
plot(getData("/net2") )
modelFile(
    '("/project/linuxlab/cadence/CDK/ncsu/models/spectre/nom/ami06N.m" "")
    '("/project/linuxlab/cadence/CDK/ncsu/models/spectre/nom/ami06P.m" "")
)
run()
selectResult( 'tran )
plot(getData("/net2") )
modelFile(
    '("/project/linuxlab/cadence/CDK/ncsu/models/spectre/nom/ami06N.m" "")
    '("/project/linuxlab/cadence/CDK/ncsu/models/spectre/nom/ami06P.m" "")
)
run()
selectResult( 'tran )
plot(getData("/net03") getData("/net2") )
modelFile(
    '("/project/linuxlab/cadence/CDK/ncsu/models/spectre/nom/ami06N.m" "")
    '("/project/linuxlab/cadence/CDK/ncsu/models/spectre/nom/ami06P.m" "")
)
analysis('tran ?stop "2000u"  )
run()
selectResult( 'tran )
plot(getData("/net2") getData("/net03") )
modelFile(
    '("/project/linuxlab/cadence/CDK/ncsu/models/spectre/nom/ami06N.m" "")
    '("/project/linuxlab/cadence/CDK/ncsu/models/spectre/nom/ami06P.m" "")
)
run()
selectResult( 'tran )
plot(getData("/net2") getData("/net03") )
modelFile(
    '("/project/linuxlab/cadence/CDK/ncsu/models/spectre/nom/ami06N.m" "")
    '("/project/linuxlab/cadence/CDK/ncsu/models/spectre/nom/ami06P.m" "")
)
run()
selectResult( 'tran )
plot(getData("/net2") getData("/net03") )
modelFile(
    '("/project/linuxlab/cadence/CDK/ncsu/models/spectre/nom/ami06N.m" "")
    '("/project/linuxlab/cadence/CDK/ncsu/models/spectre/nom/ami06P.m" "")
)
run()
selectResult( 'tran )
plot(getData("/net2") )
modelFile(
    '("/project/linuxlab/cadence/CDK/ncsu/models/spectre/nom/ami06N.m" "")
    '("/project/linuxlab/cadence/CDK/ncsu/models/spectre/nom/ami06P.m" "")
)
analysis('tran ?stop "20u"  )
run()
selectResult( 'tran )
plot(getData("/net2") )
modelFile(
    '("/project/linuxlab/cadence/CDK/ncsu/models/spectre/nom/ami06N.m" "")
    '("/project/linuxlab/cadence/CDK/ncsu/models/spectre/nom/ami06P.m" "")
)
run()
selectResult( 'tran )
plot(getData("/net2") getData("/net03") )
modelFile(
    '("/project/linuxlab/cadence/CDK/ncsu/models/spectre/nom/ami06N.m" "")
    '("/project/linuxlab/cadence/CDK/ncsu/models/spectre/nom/ami06P.m" "")
)
analysis('tran ?stop "5u"  )
run()
selectResult( 'tran )
plot(getData("/net2") getData("/net03") )
modelFile(
    '("/project/linuxlab/cadence/CDK/ncsu/models/spectre/nom/ami06N.m" "")
    '("/project/linuxlab/cadence/CDK/ncsu/models/spectre/nom/ami06P.m" "")
)
run()
selectResult( 'tran )
plot(getData("/net2") getData("/net03") )
modelFile(
    '("/project/linuxlab/cadence/CDK/ncsu/models/spectre/nom/ami06N.m" "")
    '("/project/linuxlab/cadence/CDK/ncsu/models/spectre/nom/ami06P.m" "")
)
run()
selectResult( 'tran )
plot(getData("/net2") getData("/net03") )
modelFile(
    '("/project/linuxlab/cadence/CDK/ncsu/models/spectre/nom/ami06N.m" "")
    '("/project/linuxlab/cadence/CDK/ncsu/models/spectre/nom/ami06P.m" "")
)
run()
selectResult( 'tran )
plot(getData("/net2") getData("/net03") )
modelFile(
    '("/project/linuxlab/cadence/CDK/ncsu/models/spectre/nom/ami06N.m" "")
    '("/project/linuxlab/cadence/CDK/ncsu/models/spectre/nom/ami06P.m" "")
)
run()
selectResult( 'tran )
plot(getData("/net2") getData("/net03") )
modelFile(
    '("/project/linuxlab/cadence/CDK/ncsu/models/spectre/nom/ami06N.m" "")
    '("/project/linuxlab/cadence/CDK/ncsu/models/spectre/nom/ami06P.m" "")
)
run()
selectResult( 'tran )
plot(getData("/net2") getData("/net03") )
modelFile(
    '("/project/linuxlab/cadence/CDK/ncsu/models/spectre/nom/ami06N.m" "")
    '("/project/linuxlab/cadence/CDK/ncsu/models/spectre/nom/ami06P.m" "")
)
run()
selectResult( 'tran )
plot(getData("/net2") getData("/net03") )
modelFile(
    '("/project/linuxlab/cadence/CDK/ncsu/models/spectre/nom/ami06N.m" "")
    '("/project/linuxlab/cadence/CDK/ncsu/models/spectre/nom/ami06P.m" "")
)
run()
selectResult( 'tran )
plot(getData("/net2") getData("/net03") )
modelFile(
    '("/project/linuxlab/cadence/CDK/ncsu/models/spectre/nom/ami06N.m" "")
    '("/project/linuxlab/cadence/CDK/ncsu/models/spectre/nom/ami06P.m" "")
)
run()
selectResult( 'tran )
plot(getData("/net2") getData("/net03") )
modelFile(
    '("/project/linuxlab/cadence/CDK/ncsu/models/spectre/nom/ami06N.m" "")
    '("/project/linuxlab/cadence/CDK/ncsu/models/spectre/nom/ami06P.m" "")
)
run()
selectResult( 'tran )
plot(getData("/net2") getData("/net03") )
modelFile(
    '("/project/linuxlab/cadence/CDK/ncsu/models/spectre/nom/ami06N.m" "")
    '("/project/linuxlab/cadence/CDK/ncsu/models/spectre/nom/ami06P.m" "")
)
run()
selectResult( 'tran )
plot(getData("/net2") getData("/net03") )
modelFile(
    '("/project/linuxlab/cadence/CDK/ncsu/models/spectre/nom/ami06N.m" "")
    '("/project/linuxlab/cadence/CDK/ncsu/models/spectre/nom/ami06P.m" "")
)
run()
selectResult( 'tran )
plot(getData("/net2") getData("/net03") )
modelFile(
    '("/project/linuxlab/cadence/CDK/ncsu/models/spectre/nom/ami06N.m" "")
    '("/project/linuxlab/cadence/CDK/ncsu/models/spectre/nom/ami06P.m" "")
)
run()
selectResult( 'tran )
plot(getData("/net2") getData("/net03") )
modelFile(
    '("/project/linuxlab/cadence/CDK/ncsu/models/spectre/nom/ami06N.m" "")
    '("/project/linuxlab/cadence/CDK/ncsu/models/spectre/nom/ami06P.m" "")
)
run()
selectResult( 'tran )
plot(getData("/net2") getData("/net03") )
modelFile(
    '("/project/linuxlab/cadence/CDK/ncsu/models/spectre/nom/ami06N.m" "")
    '("/project/linuxlab/cadence/CDK/ncsu/models/spectre/nom/ami06P.m" "")
)
run()
selectResult( 'tran )
plot(getData("/net2") getData("/net03") )
modelFile(
    '("/project/linuxlab/cadence/CDK/ncsu/models/spectre/nom/ami06N.m" "")
    '("/project/linuxlab/cadence/CDK/ncsu/models/spectre/nom/ami06P.m" "")
)
run()
selectResult( 'tran )
plot(getData("/net2") getData("/net03") )
modelFile(
    '("/project/linuxlab/cadence/CDK/ncsu/models/spectre/nom/ami06N.m" "")
    '("/project/linuxlab/cadence/CDK/ncsu/models/spectre/nom/ami06P.m" "")
)
run()
selectResult( 'tran )
plot(getData("/net2") getData("/net03") )
modelFile(
    '("/project/linuxlab/cadence/CDK/ncsu/models/spectre/nom/ami06N.m" "")
    '("/project/linuxlab/cadence/CDK/ncsu/models/spectre/nom/ami06P.m" "")
)
run()
selectResult( 'tran )
plot(getData("/net2") getData("/net03") )
modelFile(
    '("/project/linuxlab/cadence/CDK/ncsu/models/spectre/nom/ami06N.m" "")
    '("/project/linuxlab/cadence/CDK/ncsu/models/spectre/nom/ami06P.m" "")
)
run()
selectResult( 'tran )
plot(getData("/net2") getData("/net03") )
modelFile(
    '("/project/linuxlab/cadence/CDK/ncsu/models/spectre/nom/ami06N.m" "")
    '("/project/linuxlab/cadence/CDK/ncsu/models/spectre/nom/ami06P.m" "")
)
run()
selectResult( 'tran )
plot(getData("/net2") getData("/net03") )
