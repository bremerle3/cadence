// Design: 563_final/2_1_mux_test
simulator lang=spectre
global 0 vdd!
include "/project/linuxlab/cadence/CDK/ncsu/models/spectre/nom/ami06N.m"
include "/project/linuxlab/cadence/CDK/ncsu/models/spectre/nom/ami06P.m"

// 563_final/2_1_mux/schematic
subckt _sub0 A B clk out
    P2 (out net10 B vdd!) ami06P w=1.8u l=1.8u m=1 region=sat
    P0 (out clk A vdd!) ami06P w=1.8u l=1.8u m=1 region=sat
    P17 (net10 clk vdd! vdd!) ami06P w=1.8u l=1.8u m=1 region=sat
    N2 (B clk out 0) ami06N w=1.8u l=1.8u m=1 region=sat
    N0 (A net10 out 0) ami06N w=1.8u l=1.8u m=1 region=sat
    N13 (net10 clk 0 0) ami06N w=1.8u l=1.8u m=1 region=sat
ends _sub0

// 563_final/2_1_mux_test/schematic
I0 (net2 net3 net4 net5) _sub0
C1 (net5 0) capacitor c=1p m=1
V5 (net4 0) vsource type=pulse val0=0 val1=5 period=5u
V6 (net3 0) vsource type=pulse val0=0 val1=5 period=10u
V4 (net2 0) vsource type=pulse val0=0 val1=5 period=20u
V0 (vdd! 0) vsource type=dc dc=5
simulatorOptions options temp=27
tran tran stop=20u
