simulator( 'spectre )
design(	 "/home/warehouse/lbremer/cadence/simulation/mirror3/spectre/schematic/netlist/netlist")
resultsDir( "/home/warehouse/lbremer/cadence/simulation/mirror3/spectre/schematic" )
modelFile(
    '("/project/linuxlab/cadence/CDK/ncsu/models/spectre/nom/ami06N.m" "")
    '("/project/linuxlab/cadence/CDK/ncsu/models/spectre/nom/ami06P.m" "")
)
analysis('dc ?saveOppoint t  ?dev "/V1"  ?param "dc"
		?start "0"  ?stop "3"  )
envOption(
	'analysisOrder  list("dc")
)
save( 'i "/N0/D" "/N1/D" )
temp( 27 )
run()
selectResult( 'dc )
plot(getData("/N0/D") getData("/N1/D") )
modelFile(
    '("/project/linuxlab/cadence/CDK/ncsu/models/spectre/nom/ami06N.m" "")
    '("/project/linuxlab/cadence/CDK/ncsu/models/spectre/nom/ami06P.m" "")
)
desVar(	  "tL" 600n	)
desVar(	  "tW" 900n	)
run()
selectResult( 'dc )
plot(getData("/N0/D") getData("/N1/D") )
modelFile(
    '("/project/linuxlab/cadence/CDK/ncsu/models/spectre/nom/ami06N.m" "")
    '("/project/linuxlab/cadence/CDK/ncsu/models/spectre/nom/ami06P.m" "")
)
desVar(	  "tL" .5u	)
desVar(	  "tW" 15u	)
run()
selectResult( 'dc )
plot(getData("/N0/D") getData("/N1/D") )
modelFile(
    '("/project/linuxlab/cadence/CDK/ncsu/models/spectre/nom/ami06N.m" "")
    '("/project/linuxlab/cadence/CDK/ncsu/models/spectre/nom/ami06P.m" "")
)
analysis('dc ?stop "500n"  )
run()
selectResult( 'dc )
plot(getData("/N0/D") getData("/N1/D") )
modelFile(
    '("/project/linuxlab/cadence/CDK/ncsu/models/spectre/nom/ami06N.m" "")
    '("/project/linuxlab/cadence/CDK/ncsu/models/spectre/nom/ami06P.m" "")
)
analysis('dc ?stop "3"  )
run()
selectResult( 'dc )
plot(getData("/N0/D") getData("/N1/D") )
