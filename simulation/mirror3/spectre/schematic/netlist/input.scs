// Design: cse562/mirror3
simulator lang=spectre
global 0 vdd!
parameters tW=15u tL=.5u
include "/project/linuxlab/cadence/CDK/ncsu/models/spectre/nom/ami06N.m"
include "/project/linuxlab/cadence/CDK/ncsu/models/spectre/nom/ami06P.m"

// cse562/mirror3/schematic
N0 (net1 net1 0 0) ami06N w=tW l=tL m=1 region=sat
N1 (net7 net1 0 0) ami06N w=tW l=tL m=1 region=sat
V1 (net7 0) vsource type=dc
V0 (vdd! 0) vsource type=dc dc=3
R0 (vdd! net1) resistor r=50K m=1
simulatorOptions options temp=27
dcOp dc
dc dc dev=V1 param=dc start=0 stop=3
save N0:d N1:d
