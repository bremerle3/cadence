// Design: cse562/trans_gate_latch
simulator lang=spectre
global 0 vdd!
parameters nW=900n nL=600n pW=900n pL=600n
include "/project/linuxlab/cadence/CDK/ncsu/models/spectre/nom/ami06N.m"
include "/project/linuxlab/cadence/CDK/ncsu/models/spectre/nom/ami06P.m"

// cse562/trans_gate_latch/schematic
V0 (vdd! 0) vsource type=dc dc=3v
N7 (net023 net040 net050 0) ami06N w=nW l=nL m=1 region=sat
N4 (net023 net021 0 0) ami06N w=nW l=nL m=1 region=sat
N2 (net021 net050 0 0) ami06N w=nW l=nL m=1 region=sat
N1 (net03 net040 0 0) ami06N w=nW l=nL m=1 region=sat
N0 (net018 net03 net050 0) ami06N w=nW l=nL m=1 region=sat
P8 (net050 net03 net023 vdd!) ami06P w=pW l=pL m=1 region=sat
P3 (net023 net021 vdd! vdd!) ami06P w=pW l=pL m=1 region=sat
P2 (net021 net050 vdd! vdd!) ami06P w=pW l=pL m=1 region=sat
P1 (net03 net040 vdd! vdd!) ami06P w=pW l=pL m=1 region=sat
P0 (net050 net040 net018 vdd!) ami06P w=pW l=pL m=1 region=sat
V4 (net040 0) vsource type=pulse val0=0 val1=3 period=4u delay=100n rise=2.0p fall=2.0p width=2u
V3 (net018 0) vsource type=pulse val0=0 val1=3 period=4u rise=200.000p fall=200.000p width=2u
simulatorOptions options temp=27
tran tran stop=16u
