// Design: cse562/volt_mode
simulator lang=spectre
global 0 vdd!
parameters nW=900n nL=600n pW=900n pL=600n
include "/project/linuxlab/cadence/CDK/ncsu/models/spectre/nom/ami06N.m"
include "/project/linuxlab/cadence/CDK/ncsu/models/spectre/nom/ami06P.m"

// cse562/comparator/schematic
subckt comparator V\+ V\- Vout
    I27 (vdd! net2) isource type=dc dc=200n m=1
    N2 (Vout net15 0 0) ami06N w=nW l=nL m=1 region=sat
    N1 (net15 V\+ net5 net5) ami06N w=nW l=nL m=1 region=sat
    N17 (net3 V\- net5 net5) ami06N w=nW l=nL m=1 region=sat
    N15 (net5 net2 net9 net9) ami06N w=nW l=nL m=1 region=sat
    N14 (net2 net2 net1 net1) ami06N w=nW l=nL m=1 region=sat
    N13 (net9 net1 0 0) ami06N w=nW l=nL m=1 region=sat
    N12 (net1 net1 0 0) ami06N w=nW l=nL m=1 region=sat
    P4 (net15 net3 vdd! vdd!) ami06P w=pW l=pL m=1 region=sat
    P5 (Vout net15 vdd! vdd!) ami06P w=pW l=pL m=1 region=sat
    P2 (net3 net3 vdd! vdd!) ami06P w=pW l=pL m=1 region=sat
ends comparator

// cse562/true_ff/schematic
subckt true_ff CLK D Q
    N6 (Q net7 0 0) ami06N w=nW l=nL m=1 region=sat
    N5 (net19 net5 0 0) ami06N w=nW l=nL m=1 region=sat
    N4 (net7 CLK net19 net19) ami06N w=nW l=nL m=1 region=sat
    N3 (net5 net3 net15 net15) ami06N w=nW l=nL m=1 region=sat
    N2 (net15 CLK 0 0) ami06N w=nW l=nL m=1 region=sat
    N1 (net3 D 0 0) ami06N w=nW l=nL m=1 region=sat
    P9 (Q net7 vdd! vdd!) ami06P w=pW l=pL m=1 region=sat
    P7 (net7 net5 vdd! vdd!) ami06P w=pW l=pL m=1 region=sat
    P5 (net5 CLK vdd! vdd!) ami06P w=pW l=pL m=1 region=sat
    P4 (net3 CLK net10 net10) ami06P w=pW l=pL m=1 region=sat
    P1 (net10 D vdd! vdd!) ami06P w=pW l=pL m=1 region=sat
ends true_ff

// cse562/volt_mode/schematic
N1 (net7 net5 0 0) ami06N w=nW l=nL m=1 region=sat
N0 (net5 net3 0 0) ami06N w=nW l=nL m=1 region=sat
N7 (net3 net2 0 0) ami06N w=nW l=nL m=1 region=sat
P1 (net7 net5 vdd! vdd!) ami06P w=pW l=pL m=1 region=sat
P0 (net5 net3 vdd! vdd!) ami06P w=pW l=pL m=1 region=sat
P8 (net3 net2 vdd! vdd!) ami06P w=pW l=pL m=1 region=sat
I46 (net1 net9 net20) comparator
V4 (net9 0) vsource type=dc dc=2.5
V0 (vdd! 0) vsource type=dc dc=5
R1 (net019 net1) resistor r=500kM m=1
R0 (net1 net7) resistor r=500K m=1
C0 (net1 0) capacitor c=1p m=1
I47 (net10 net20 net2) true_ff
V2 (net10 0) vsource type=pulse val0=0 val1=5 period=500u rise=100.0f fall=100.0f width=250u
V1 (net019 0) vsource type=pwl wave=[ 0 0 500m 1 ]
simulatorOptions options temp=27
tran tran stop=500000u
