simulator( 'spectre )
design(	 "/home/warehouse/lbremer/cadence/simulation/volt_mode/spectre/schematic/netlist/netlist")
resultsDir( "/home/warehouse/lbremer/cadence/simulation/volt_mode/spectre/schematic" )
modelFile(
    '("/project/linuxlab/cadence/CDK/ncsu/models/spectre/nom/ami06N.m" "")
    '("/project/linuxlab/cadence/CDK/ncsu/models/spectre/nom/ami06P.m" "")
)
analysis('tran ?stop "100u"  )
envOption(
	'analysisOrder  list("tran")
)
temp( 27 )
run()
selectResult( 'tran )
plot(getData("/net21") getData("/vdd!") )
modelFile(
    '("/project/linuxlab/cadence/CDK/ncsu/models/spectre/nom/ami06N.m" "")
    '("/project/linuxlab/cadence/CDK/ncsu/models/spectre/nom/ami06P.m" "")
)
desVar(	  "pL" 600n	)
desVar(	  "pW" 900n	)
desVar(	  "nL" 600n	)
desVar(	  "nW" 900n	)
run()
selectResult( 'tran )
plot(getData("/net21") getData("/vdd!") )
modelFile(
    '("/project/linuxlab/cadence/CDK/ncsu/models/spectre/nom/ami06N.m" "")
    '("/project/linuxlab/cadence/CDK/ncsu/models/spectre/nom/ami06P.m" "")
)
run()
selectResult( 'tran )
plot(getData("/net21") getData("/vdd!") )
modelFile(
    '("/project/linuxlab/cadence/CDK/ncsu/models/spectre/nom/ami06N.m" "")
    '("/project/linuxlab/cadence/CDK/ncsu/models/spectre/nom/ami06P.m" "")
)
run()
selectResult( 'tran )
plot(getData("/net21") getData("/net09") )
modelFile(
    '("/project/linuxlab/cadence/CDK/ncsu/models/spectre/nom/ami06N.m" "")
    '("/project/linuxlab/cadence/CDK/ncsu/models/spectre/nom/ami06P.m" "")
)
run()
selectResult( 'tran )
plot(getData("/net012") getData("/net032") )
modelFile(
    '("/project/linuxlab/cadence/CDK/ncsu/models/spectre/nom/ami06N.m" "")
    '("/project/linuxlab/cadence/CDK/ncsu/models/spectre/nom/ami06P.m" "")
)
run()
selectResult( 'tran )
plot(getData("/net016") getData("/net031") getData("/net012") )
modelFile(
    '("/project/linuxlab/cadence/CDK/ncsu/models/spectre/nom/ami06N.m" "")
    '("/project/linuxlab/cadence/CDK/ncsu/models/spectre/nom/ami06P.m" "")
)
run()
selectResult( 'tran )
plot(getData("/net031") getData("/net016") )
modelFile(
    '("/project/linuxlab/cadence/CDK/ncsu/models/spectre/nom/ami06N.m" "")
    '("/project/linuxlab/cadence/CDK/ncsu/models/spectre/nom/ami06P.m" "")
)
run()
selectResult( 'tran )
plot(getData("/net031") getData("/net016") )
modelFile(
    '("/project/linuxlab/cadence/CDK/ncsu/models/spectre/nom/ami06N.m" "")
    '("/project/linuxlab/cadence/CDK/ncsu/models/spectre/nom/ami06P.m" "")
)
analysis('dc ?saveOppoint t  ?dev "/V5"  ?param "dc"
		?start "0"  ?stop "3"  )
envOption(
	'analysisOrder  list("tran" "dc")
)
run()
selectResult( 'dc )
plot(getData("/net031") getData("/net016") )
modelFile(
    '("/project/linuxlab/cadence/CDK/ncsu/models/spectre/nom/ami06N.m" "")
    '("/project/linuxlab/cadence/CDK/ncsu/models/spectre/nom/ami06P.m" "")
)
run()
selectResult( 'dc )
plot(getData("/net011") getData("/net029") )
modelFile(
    '("/project/linuxlab/cadence/CDK/ncsu/models/spectre/nom/ami06N.m" "")
    '("/project/linuxlab/cadence/CDK/ncsu/models/spectre/nom/ami06P.m" "")
)
run()
selectResult( 'dc )
plot(getData("/net013") getData("/net031") )
modelFile(
    '("/project/linuxlab/cadence/CDK/ncsu/models/spectre/nom/ami06N.m" "")
    '("/project/linuxlab/cadence/CDK/ncsu/models/spectre/nom/ami06P.m" "")
)
analysis('tran ?stop "100u"  )
run()
selectResult( 'tran )
plot(getData("/net031") getData("/net013") )
modelFile(
    '("/project/linuxlab/cadence/CDK/ncsu/models/spectre/nom/ami06N.m" "")
    '("/project/linuxlab/cadence/CDK/ncsu/models/spectre/nom/ami06P.m" "")
)
run()
selectResult( 'tran )
plot(getData("/net031") getData("/net013") )
modelFile(
    '("/project/linuxlab/cadence/CDK/ncsu/models/spectre/nom/ami06N.m" "")
    '("/project/linuxlab/cadence/CDK/ncsu/models/spectre/nom/ami06P.m" "")
)
run()
selectResult( 'tran )
plot(getData("/net031") getData("/net013") )
modelFile(
    '("/project/linuxlab/cadence/CDK/ncsu/models/spectre/nom/ami06N.m" "")
    '("/project/linuxlab/cadence/CDK/ncsu/models/spectre/nom/ami06P.m" "")
)
save( 'i "/I32/PLUS" "/P10/D" )
run()
selectResult( 'tran )
plot(getData("/I32/PLUS") getData("/P10/D") )
modelFile(
    '("/project/linuxlab/cadence/CDK/ncsu/models/spectre/nom/ami06N.m" "")
    '("/project/linuxlab/cadence/CDK/ncsu/models/spectre/nom/ami06P.m" "")
)
run()
selectResult( 'tran )
plot(getData("/net5") getData("/net061") getData("/I32/PLUS") getData("/P10/D") )
modelFile(
    '("/project/linuxlab/cadence/CDK/ncsu/models/spectre/nom/ami06N.m" "")
    '("/project/linuxlab/cadence/CDK/ncsu/models/spectre/nom/ami06P.m" "")
)
save( 'i "/R4/MINUS" )
run()
selectResult( 'tran )
plot(getData("/I32/PLUS") getData("/net061") getData("/R4/MINUS") )
modelFile(
    '("/project/linuxlab/cadence/CDK/ncsu/models/spectre/nom/ami06N.m" "")
    '("/project/linuxlab/cadence/CDK/ncsu/models/spectre/nom/ami06P.m" "")
)
save( 'i /P10/D )
run()
selectResult( 'tran )
plot(getData("/I32/PLUS") getData("/R4/MINUS") getData("/net031") getData("/net013") )
modelFile(
    '("/project/linuxlab/cadence/CDK/ncsu/models/spectre/nom/ami06N.m" "")
    '("/project/linuxlab/cadence/CDK/ncsu/models/spectre/nom/ami06P.m" "")
)
run()
selectResult( 'tran )
plot(getData("/I32/PLUS") getData("/R4/MINUS") getData("/net031") getData("/net013") )
modelFile(
    '("/project/linuxlab/cadence/CDK/ncsu/models/spectre/nom/ami06N.m" "")
    '("/project/linuxlab/cadence/CDK/ncsu/models/spectre/nom/ami06P.m" "")
)
run()
selectResult( 'tran )
plot(getData("/I32/PLUS") getData("/R4/MINUS") getData("/net031") getData("/net013") )
modelFile(
    '("/project/linuxlab/cadence/CDK/ncsu/models/spectre/nom/ami06N.m" "")
    '("/project/linuxlab/cadence/CDK/ncsu/models/spectre/nom/ami06P.m" "")
)
run()
selectResult( 'tran )
plot(getData("/I32/PLUS") getData("/R4/MINUS") getData("/net031") getData("/net013") )
modelFile(
    '("/project/linuxlab/cadence/CDK/ncsu/models/spectre/nom/ami06N.m" "")
    '("/project/linuxlab/cadence/CDK/ncsu/models/spectre/nom/ami06P.m" "")
)
run()
selectResult( 'tran )
plot(getData("/I32/PLUS") getData("/R4/MINUS") getData("/net031") getData("/net013") )
modelFile(
    '("/project/linuxlab/cadence/CDK/ncsu/models/spectre/nom/ami06N.m" "")
    '("/project/linuxlab/cadence/CDK/ncsu/models/spectre/nom/ami06P.m" "")
)
run()
selectResult( 'tran )
plot(getData("/I32/PLUS") getData("/R4/MINUS") getData("/net031") getData("/net013") )
modelFile(
    '("/project/linuxlab/cadence/CDK/ncsu/models/spectre/nom/ami06N.m" "")
    '("/project/linuxlab/cadence/CDK/ncsu/models/spectre/nom/ami06P.m" "")
)
run()
selectResult( 'tran )
plot(getData("/I32/PLUS") getData("/R4/MINUS") getData("/net031") getData("/net013") )
modelFile(
    '("/project/linuxlab/cadence/CDK/ncsu/models/spectre/nom/ami06N.m" "")
    '("/project/linuxlab/cadence/CDK/ncsu/models/spectre/nom/ami06P.m" "")
)
save( 'i /I32/PLUS /R4/MINUS )
run()
selectResult( 'tran )
plot(getData("/net019") getData("/net040") )
modelFile(
    '("/project/linuxlab/cadence/CDK/ncsu/models/spectre/nom/ami06N.m" "")
    '("/project/linuxlab/cadence/CDK/ncsu/models/spectre/nom/ami06P.m" "")
)
run()
selectResult( 'tran )
plot(getData("/net031") getData("/net040") getData("/net019") )
modelFile(
    '("/project/linuxlab/cadence/CDK/ncsu/models/spectre/nom/ami06N.m" "")
    '("/project/linuxlab/cadence/CDK/ncsu/models/spectre/nom/ami06P.m" "")
)
run()
selectResult( 'tran )
plot(getData("/net08") getData("/net031") )
modelFile(
    '("/project/linuxlab/cadence/CDK/ncsu/models/spectre/nom/ami06N.m" "")
    '("/project/linuxlab/cadence/CDK/ncsu/models/spectre/nom/ami06P.m" "")
)
run()
selectResult( 'tran )
plot(getData("/net20") getData("/net5") getData("/net019") )
modelFile(
    '("/project/linuxlab/cadence/CDK/ncsu/models/spectre/nom/ami06N.m" "")
    '("/project/linuxlab/cadence/CDK/ncsu/models/spectre/nom/ami06P.m" "")
)
run()
selectResult( 'tran )
plot(getData("/net019") getData("/net5") getData("/net20") )
modelFile(
    '("/project/linuxlab/cadence/CDK/ncsu/models/spectre/nom/ami06N.m" "")
    '("/project/linuxlab/cadence/CDK/ncsu/models/spectre/nom/ami06P.m" "")
)
save( 'v "/net5" )
run()
selectResult( 'tran )
plot(getData("/net5") )
modelFile(
    '("/project/linuxlab/cadence/CDK/ncsu/models/spectre/nom/ami06N.m" "")
    '("/project/linuxlab/cadence/CDK/ncsu/models/spectre/nom/ami06P.m" "")
)
run()
selectResult( 'tran )
plot(getData("/net5") )
modelFile(
    '("/project/linuxlab/cadence/CDK/ncsu/models/spectre/nom/ami06N.m" "")
    '("/project/linuxlab/cadence/CDK/ncsu/models/spectre/nom/ami06P.m" "")
)
run()
selectResult( 'tran )
plot(getData("/net5") )
modelFile(
    '("/project/linuxlab/cadence/CDK/ncsu/models/spectre/nom/ami06N.m" "")
    '("/project/linuxlab/cadence/CDK/ncsu/models/spectre/nom/ami06P.m" "")
)
delete( 'save 'v /net5 )
run()
selectResult( 'tran )
plot(getData("/net5") getData("/net019") )
modelFile(
    '("/project/linuxlab/cadence/CDK/ncsu/models/spectre/nom/ami06N.m" "")
    '("/project/linuxlab/cadence/CDK/ncsu/models/spectre/nom/ami06P.m" "")
)
run()
selectResult( 'tran )
plot(getData("/net5") getData("/net019") )
modelFile(
    '("/project/linuxlab/cadence/CDK/ncsu/models/spectre/nom/ami06N.m" "")
    '("/project/linuxlab/cadence/CDK/ncsu/models/spectre/nom/ami06P.m" "")
)
run()
selectResult( 'tran )
plot(getData("/net019") getData("/net5") )
modelFile(
    '("/project/linuxlab/cadence/CDK/ncsu/models/spectre/nom/ami06N.m" "")
    '("/project/linuxlab/cadence/CDK/ncsu/models/spectre/nom/ami06P.m" "")
)
run()
selectResult( 'tran )
plot(getData("/net019") getData("/net5") )
modelFile(
    '("/project/linuxlab/cadence/CDK/ncsu/models/spectre/nom/ami06N.m" "")
    '("/project/linuxlab/cadence/CDK/ncsu/models/spectre/nom/ami06P.m" "")
)
run()
selectResult( 'tran )
plot(getData("/net019") getData("/net5") )
modelFile(
    '("/project/linuxlab/cadence/CDK/ncsu/models/spectre/nom/ami06N.m" "")
    '("/project/linuxlab/cadence/CDK/ncsu/models/spectre/nom/ami06P.m" "")
)
run()
selectResult( 'tran )
plot(getData("/net019") getData("/net5") )
modelFile(
    '("/project/linuxlab/cadence/CDK/ncsu/models/spectre/nom/ami06N.m" "")
    '("/project/linuxlab/cadence/CDK/ncsu/models/spectre/nom/ami06P.m" "")
)
run()
selectResult( 'tran )
plot(getData("/net019") getData("/net5") )
modelFile(
    '("/project/linuxlab/cadence/CDK/ncsu/models/spectre/nom/ami06N.m" "")
    '("/project/linuxlab/cadence/CDK/ncsu/models/spectre/nom/ami06P.m" "")
)
run()
selectResult( 'tran )
plot(getData("/net1") )
modelFile(
    '("/project/linuxlab/cadence/CDK/ncsu/models/spectre/nom/ami06N.m" "")
    '("/project/linuxlab/cadence/CDK/ncsu/models/spectre/nom/ami06P.m" "")
)
run()
selectResult( 'tran )
plot(getData("/net1") )
modelFile(
    '("/project/linuxlab/cadence/CDK/ncsu/models/spectre/nom/ami06N.m" "")
    '("/project/linuxlab/cadence/CDK/ncsu/models/spectre/nom/ami06P.m" "")
)
run()
selectResult( 'tran )
plot(getData("/net1") )
modelFile(
    '("/project/linuxlab/cadence/CDK/ncsu/models/spectre/nom/ami06N.m" "")
    '("/project/linuxlab/cadence/CDK/ncsu/models/spectre/nom/ami06P.m" "")
)
run()
selectResult( 'tran )
plot(getData("/net1") )
modelFile(
    '("/project/linuxlab/cadence/CDK/ncsu/models/spectre/nom/ami06N.m" "")
    '("/project/linuxlab/cadence/CDK/ncsu/models/spectre/nom/ami06P.m" "")
)
run()
selectResult( 'tran )
plot(getData("/net1") )
modelFile(
    '("/project/linuxlab/cadence/CDK/ncsu/models/spectre/nom/ami06N.m" "")
    '("/project/linuxlab/cadence/CDK/ncsu/models/spectre/nom/ami06P.m" "")
)
run()
selectResult( 'tran )
plot(getData("/net1") )
modelFile(
    '("/project/linuxlab/cadence/CDK/ncsu/models/spectre/nom/ami06N.m" "")
    '("/project/linuxlab/cadence/CDK/ncsu/models/spectre/nom/ami06P.m" "")
)
run()
selectResult( 'tran )
plot(getData("/net1") )
modelFile(
    '("/project/linuxlab/cadence/CDK/ncsu/models/spectre/nom/ami06N.m" "")
    '("/project/linuxlab/cadence/CDK/ncsu/models/spectre/nom/ami06P.m" "")
)
run()
selectResult( 'tran )
plot(getData("/net1") )
modelFile(
    '("/project/linuxlab/cadence/CDK/ncsu/models/spectre/nom/ami06N.m" "")
    '("/project/linuxlab/cadence/CDK/ncsu/models/spectre/nom/ami06P.m" "")
)
run()
selectResult( 'tran )
plot(getData("/net1") )
modelFile(
    '("/project/linuxlab/cadence/CDK/ncsu/models/spectre/nom/ami06N.m" "")
    '("/project/linuxlab/cadence/CDK/ncsu/models/spectre/nom/ami06P.m" "")
)
run()
selectResult( 'tran )
plot(getData("/net1") )
modelFile(
    '("/project/linuxlab/cadence/CDK/ncsu/models/spectre/nom/ami06N.m" "")
    '("/project/linuxlab/cadence/CDK/ncsu/models/spectre/nom/ami06P.m" "")
)
run()
selectResult( 'tran )
plot(getData("/net5") )
modelFile(
    '("/project/linuxlab/cadence/CDK/ncsu/models/spectre/nom/ami06N.m" "")
    '("/project/linuxlab/cadence/CDK/ncsu/models/spectre/nom/ami06P.m" "")
)
run()
selectResult( 'tran )
plot(getData("/net5") )
modelFile(
    '("/project/linuxlab/cadence/CDK/ncsu/models/spectre/nom/ami06N.m" "")
    '("/project/linuxlab/cadence/CDK/ncsu/models/spectre/nom/ami06P.m" "")
)
analysis('tran ?stop "50m"  )
run()
selectResult( 'tran )
plot(getData("/net5") )
modelFile(
    '("/project/linuxlab/cadence/CDK/ncsu/models/spectre/nom/ami06N.m" "")
    '("/project/linuxlab/cadence/CDK/ncsu/models/spectre/nom/ami06P.m" "")
)
run()
selectResult( 'tran )
plot(getData("/net5") )
modelFile(
    '("/project/linuxlab/cadence/CDK/ncsu/models/spectre/nom/ami06N.m" "")
    '("/project/linuxlab/cadence/CDK/ncsu/models/spectre/nom/ami06P.m" "")
)
analysis('tran ?stop "50000u"  )
delete( 'desVar "ms" )
run()
selectResult( 'tran )
plot(getData("/net5") )
modelFile(
    '("/project/linuxlab/cadence/CDK/ncsu/models/spectre/nom/ami06N.m" "")
    '("/project/linuxlab/cadence/CDK/ncsu/models/spectre/nom/ami06P.m" "")
)
analysis('tran ?stop "500000u"  )
run()
selectResult( 'tran )
plot(getData("/net5") )
