simulator( 'spectre )
design(	 "/home/warehouse/lbremer/cadence/simulation/pmos_threshold/spectre/schematic/netlist/netlist")
resultsDir( "/home/warehouse/lbremer/cadence/simulation/pmos_threshold/spectre/schematic" )
modelFile(
    '("/project/linuxlab/cadence/CDK/ncsu/models/spectre/nom/ami06N.m" "")
    '("/project/linuxlab/cadence/CDK/ncsu/models/spectre/nom/ami06P.m" "")
)
analysis('dc ?saveOppoint t  ?dev "/V_gs"  ?param "dc"
		?start "5"  ?stop "0"  )
envOption(
	'analysisOrder  list("dc")
)
save( 'i "/P0/S" )
temp( 27 )
run()
selectResult( 'dc )
plot(getData("/P0/S") )
modelFile(
    '("/project/linuxlab/cadence/CDK/ncsu/models/spectre/nom/ami06N.m" "")
    '("/project/linuxlab/cadence/CDK/ncsu/models/spectre/nom/ami06P.m" "")
)
desVar(	  "pL" 9u	)
desVar(	  "pW" 900n	)
run()
selectResult( 'dc )
plot(getData("/P0/S") )
modelFile(
    '("/project/linuxlab/cadence/CDK/ncsu/models/spectre/nom/ami06N.m" "")
    '("/project/linuxlab/cadence/CDK/ncsu/models/spectre/nom/ami06P.m" "")
)
analysis('dc ?stop "3"  )
run()
selectResult( 'dc )
plot(getData("/P0/S") )
modelFile(
    '("/project/linuxlab/cadence/CDK/ncsu/models/spectre/nom/ami06N.m" "")
    '("/project/linuxlab/cadence/CDK/ncsu/models/spectre/nom/ami06P.m" "")
)
desVar(	  "pL" 900n	)
run()
selectResult( 'dc )
plot(getData("/P0/S") )
