// Design: cse563/pmos_threshold
simulator lang=spectre
global 0
parameters pW=900n pL=900n
include "/project/linuxlab/cadence/CDK/ncsu/models/spectre/nom/ami06N.m"
include "/project/linuxlab/cadence/CDK/ncsu/models/spectre/nom/ami06P.m"

// cse563/pmos_threshold/schematic
V_gs (net4 0) vsource type=dc dc=2
V_ds (net1 0) vsource type=dc dc=5
P0 (0 net4 net1 net1) ami06P w=pW l=pL m=1 region=sat
simulatorOptions options temp=27
dcOp dc
dc dc dev=V_gs param=dc start=5 stop=3
save P0:s
