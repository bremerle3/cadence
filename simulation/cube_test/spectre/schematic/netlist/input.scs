// Design: cse562/cube_test
simulator lang=spectre
global 0 vdd!
include "/project/linuxlab/cadence/CDK/ncsu/models/spectre/nom/ami06N.m"
include "/project/linuxlab/cadence/CDK/ncsu/models/spectre/nom/ami06P.m"

// cse562/cube/schematic
subckt cube In Out
    I1 (net1 0) isource type=dc dc=50n m=1
    N5 (Out net1 0 net12) ami06N w=900n l=600n m=1 region=sat
    N4 (vdd! In net3 0) ami06N w=900n l=600n m=1 region=sat
    N3 (net3 net3 net1 0) ami06N w=900n l=600n m=1 region=sat
    N2 (net17 net17 0 0) ami06N w=900n l=600n m=1 region=sat
    N1 (net9 net9 net17 0) ami06N w=900n l=600n m=1 region=sat
    N0 (In In net9 0) ami06N w=900n l=600n m=1 region=sat
ends cube

// cse562/cube_test/schematic
I0 (net1 net5) cube
I5 (net1 0) isource type=dc dc=5m m=1
V0 (vdd! 0) vsource type=dc
simulatorOptions options temp=27
dcOp dc
dc dc dev=I5 param=dc start=-50m stop=50m
save I0:1 I0:2
