simulator( 'spectre )
design(	 "/home/warehouse/lbremer/cadence/simulation/polynomial/spectre/schematic/netlist/netlist")
resultsDir( "/home/warehouse/lbremer/cadence/simulation/polynomial/spectre/schematic" )
modelFile(
    '("/project/linuxlab/cadence/CDK/ncsu/models/spectre/nom/ami06N.m" "")
    '("/project/linuxlab/cadence/CDK/ncsu/models/spectre/nom/ami06P.m" "")
)
analysis('dc ?saveOppoint t  ?dev "/Input"  ?param "dc"
		?start "0"  ?stop "60n"  )
envOption(
	'analysisOrder  list("dc")
)
save( 'i "/P15/D" "/I8/Squared" "/N11/D" )
temp( 27 )
run()
selectResult( 'dc )
plot(getData("/P15/D") getData("/I8/Squared") getData("/N11/D") )
modelFile(
    '("/project/linuxlab/cadence/CDK/ncsu/models/spectre/nom/ami06N.m" "")
    '("/project/linuxlab/cadence/CDK/ncsu/models/spectre/nom/ami06P.m" "")
)
desVar(	  "nL" 2u	)
desVar(	  "nW" 2.4u	)
desVar(	  "pL" 2u	)
desVar(	  "pW" 2.4u	)
run()
selectResult( 'dc )
plot(getData("/P15/D") getData("/I8/Squared") getData("/N11/D") )
