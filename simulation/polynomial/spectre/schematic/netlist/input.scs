// Design: cse562/polynomial
simulator lang=spectre
global 0 vdd!
parameters pW=2.4u pL=2u nW=2.4u nL=2u
include "/project/linuxlab/cadence/CDK/ncsu/models/spectre/nom/ami06N.m"
include "/project/linuxlab/cadence/CDK/ncsu/models/spectre/nom/ami06P.m"

// cse562/squarer/schematic
subckt squarer I_In I_Out I_o Squared
    M4 (0 I_Out I_o vdd!) ami06P w=pW l=pL m=1 region=sat
    M1 (0 I_Out I_In vdd!) ami06P w=pW l=pL m=1 region=sat
    M3 (Squared I_o vdd! vdd!) ami06P w=pW l=pL m=1 region=sat
    M2 (I_Out I_In vdd! vdd!) ami06P w=pW l=pL m=1 region=sat
ends squarer

// cse562/polynomial/schematic
Input (0 net1) isource type=dc m=1
Bias (net6 0) isource type=dc dc=60n m=1
P23 (net027 net049 vdd! vdd!) ami06P w=pW l=pL m=1 region=sat
P24 (0 net050 vdd! vdd!) ami06P w=pW l=pL m=1 region=sat
P22 (net049 net049 vdd! vdd!) ami06P w=pW l=pL m=1 region=sat
P21 (net050 net050 vdd! vdd!) ami06P w=pW l=pL m=1 region=sat
P10 (net13 net13 vdd! vdd!) ami06P w=pW l=pL m=1 region=sat
P11 (net33 net13 vdd! vdd!) ami06P w=pW l=pL m=1 region=sat
P20 (net20 net13 vdd! vdd!) ami06P w=pW l=2*pL m=1 region=sat
P14 (net20 net13 vdd! vdd!) ami06P w=pW l=2*pL m=1 region=sat
P19 (net20 net13 vdd! vdd!) ami06P w=pW l=2*pL m=1 region=sat
P1 (net45 net10 vdd! vdd!) ami06P w=pW l=pL m=1 region=sat
P15 (net025 net10 vdd! vdd!) ami06P w=pW l=2*pL m=1 region=sat
P0 (net10 net10 vdd! vdd!) ami06P w=pW l=pL m=1 region=sat
P5 (net32 net6 vdd! vdd!) ami06P w=pW l=pL m=1 region=sat
P3 (net6 net6 vdd! vdd!) ami06P w=pW l=pL m=1 region=sat
P2 (net25 net6 vdd! vdd!) ami06P w=pW l=pL m=1 region=sat
N23 (0 net027 0 0) ami06N w=nW l=nL m=1 region=sat
N24 (net027 net027 0 0) ami06N w=nW l=nL m=1 region=sat
N21 (net050 net048 0 0) ami06N w=nW l=nL m=1 region=sat
N22 (net049 net20 0 0) ami06N w=nW l=nL m=1 region=sat
N11 (net20 net20 0 0) ami06N w=nW l=nL m=1 region=sat
N2 (net29 net1 0 0) ami06N w=nW l=nL m=1 region=sat
N3 (net38 net1 0 0) ami06N w=nW l=nL m=1 region=sat
N1 (net10 net1 0 0) ami06N w=nW l=nL m=1 region=sat
N0 (net1 net1 0 0) ami06N w=nW l=nL m=1 region=sat
N5 (net11 net11 0 0) ami06N w=nW l=nL m=1 region=sat
N6 (net13 net11 0 0) ami06N w=nW l=nL m=1 region=sat
N10 (net048 net048 0 0) ami06N w=nW l=nL m=1 region=sat
N7 (net026 net026 net048 net048) ami06N w=nW l=nL m=1 region=sat
N4 (net025 net025 net048 net048) ami06N w=nW l=nL m=1 region=sat
V0 (vdd! 0) vsource type=dc dc=3
I13 (net45 net29 net25 net11) squarer
I8 (net33 net38 net32 net026) squarer
simulatorOptions options temp=27
dcOp dc
dc dc dev=Input param=dc start=0 stop=60n
save P15:d I8:4 N11:d
