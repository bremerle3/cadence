// Design: cse562/simple_latch_test
simulator lang=spectre
global 0 vdd!
parameters nW=900n nL=600n pW=900n pL=600n
include "/project/linuxlab/cadence/CDK/ncsu/models/spectre/nom/ami06N.m"
include "/project/linuxlab/cadence/CDK/ncsu/models/spectre/nom/ami06P.m"

// cse562/simple_latch/schematic
subckt simple_latch CLK D Q
    N4 (net14 Q 0 0) ami06N w=nW l=nL m=1 region=sat
    N2 (Q net15 0 0) ami06N w=nW l=nL m=1 region=sat
    N0 (D net5 net15 0) ami06N w=nW l=nL m=1 region=sat
    N1 (net5 CLK 0 0) ami06N w=nW l=nL m=1 region=sat
    N7 (net14 CLK net15 0) ami06N w=nW l=nL m=1 region=sat
    P3 (net14 Q vdd! vdd!) ami06P w=pW l=pL m=1 region=sat
    P2 (Q net15 vdd! vdd!) ami06P w=pW l=pL m=1 region=sat
    P1 (net5 CLK vdd! vdd!) ami06P w=pW l=pL m=1 region=sat
    P0 (net15 CLK D vdd!) ami06P w=pW l=pL m=1 region=sat
    P8 (net15 net5 net14 vdd!) ami06P w=pW l=pL m=1 region=sat
ends simple_latch

// cse562/simple_latch_test/schematic
I0 (net1 net2 net3) simple_latch
C0 (net3 0) capacitor c=1p m=1
V0 (vdd! 0) vsource type=dc
V2 (net2 0) vsource type=pulse val0=0 val1=3 period=4u rise=200p fall=200p width=2u
V1 (net1 0) vsource type=pulse val0=0 val1=3 period=4u delay=100n rise=2p fall=2p width=2u
simulatorOptions options temp=27
tran tran stop=24u
