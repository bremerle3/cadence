simulator( 'spectre )
design(	 "/home/warehouse/lbremer/cadence/simulation/poly_sources/spectre/schematic/netlist/netlist")
resultsDir( "/home/warehouse/lbremer/cadence/simulation/poly_sources/spectre/schematic" )
modelFile(
    '("/project/linuxlab/cadence/CDK/ncsu/models/spectre/nom/ami06N.m" "")
    '("/project/linuxlab/cadence/CDK/ncsu/models/spectre/nom/ami06P.m" "")
)
analysis('dc ?saveOppoint t  ?dev "/I17"  ?param "dc"
		?start "0"  ?stop "5n"  )
envOption(
	'analysisOrder  list("dc")
)
save( 'i "/I17/MINUS" "/N7/D" )
temp( 27 )
run()
selectResult( 'dc )
plot(getData("/I17/MINUS") getData("/N7/D") )
modelFile(
    '("/project/linuxlab/cadence/CDK/ncsu/models/spectre/nom/ami06N.m" "")
    '("/project/linuxlab/cadence/CDK/ncsu/models/spectre/nom/ami06P.m" "")
)
run()
selectResult( 'dc )
plot(getData("/I17/MINUS") getData("/N7/D") )
modelFile(
    '("/project/linuxlab/cadence/CDK/ncsu/models/spectre/nom/ami06N.m" "")
    '("/project/linuxlab/cadence/CDK/ncsu/models/spectre/nom/ami06P.m" "")
)
save( 'i "/P0/D" )
save( 'i /I17/MINUS )
run()
selectResult( 'dc )
plot(getData("/P0/D") getData("/N7/D") )
modelFile(
    '("/project/linuxlab/cadence/CDK/ncsu/models/spectre/nom/ami06N.m" "")
    '("/project/linuxlab/cadence/CDK/ncsu/models/spectre/nom/ami06P.m" "")
)
save( 'i "/I9/MINUS" )
run()
selectResult( 'dc )
plot(getData("/P0/D") getData("/N7/D") getData("/I9/MINUS") )
modelFile(
    '("/project/linuxlab/cadence/CDK/ncsu/models/spectre/nom/ami06N.m" "")
    '("/project/linuxlab/cadence/CDK/ncsu/models/spectre/nom/ami06P.m" "")
)
analysis('dc ?dev "/I9"  )
run()
selectResult( 'dc )
plot(getData("/P0/D") getData("/N7/D") getData("/I9/MINUS") )
modelFile(
    '("/project/linuxlab/cadence/CDK/ncsu/models/spectre/nom/ami06N.m" "")
    '("/project/linuxlab/cadence/CDK/ncsu/models/spectre/nom/ami06P.m" "")
)
save( 'i "/N1/D" )
run()
selectResult( 'dc )
plot(getData("/P0/D") getData("/N7/D") getData("/I9/MINUS") getData("/N1/D") )
modelFile(
    '("/project/linuxlab/cadence/CDK/ncsu/models/spectre/nom/ami06N.m" "")
    '("/project/linuxlab/cadence/CDK/ncsu/models/spectre/nom/ami06P.m" "")
)
save( 'i "/I9/PLUS" )
save( 'i /P0/D /I9/MINUS )
run()
selectResult( 'dc )
plot(getData("/I9/PLUS") getData("/N1/D") getData("/N7/D") )
modelFile(
    '("/project/linuxlab/cadence/CDK/ncsu/models/spectre/nom/ami06N.m" "")
    '("/project/linuxlab/cadence/CDK/ncsu/models/spectre/nom/ami06P.m" "")
)
save( 'i "/P2/D" "/P0/D" )
save( 'i /N1/D /N7/D )
run()
selectResult( 'dc )
plot(getData("/I9/PLUS") getData("/P2/D") getData("/P0/D") )
modelFile(
    '("/project/linuxlab/cadence/CDK/ncsu/models/spectre/nom/ami06N.m" "")
    '("/project/linuxlab/cadence/CDK/ncsu/models/spectre/nom/ami06P.m" "")
)
save( 'i "/N7/D" "/N11/D" )
save( 'i /P2/D /P0/D )
run()
selectResult( 'dc )
plot(getData("/I9/PLUS") getData("/N7/D") getData("/N11/D") )
modelFile(
    '("/project/linuxlab/cadence/CDK/ncsu/models/spectre/nom/ami06N.m" "")
    '("/project/linuxlab/cadence/CDK/ncsu/models/spectre/nom/ami06P.m" "")
)
run()
selectResult( 'dc )
plot(getData("/I9/PLUS") getData("/N7/D") getData("/N11/D") )
modelFile(
    '("/project/linuxlab/cadence/CDK/ncsu/models/spectre/nom/ami06N.m" "")
    '("/project/linuxlab/cadence/CDK/ncsu/models/spectre/nom/ami06P.m" "")
)
run()
selectResult( 'dc )
plot(getData("/I9/PLUS") getData("/N7/D") getData("/N11/D") )
modelFile(
    '("/project/linuxlab/cadence/CDK/ncsu/models/spectre/nom/ami06N.m" "")
    '("/project/linuxlab/cadence/CDK/ncsu/models/spectre/nom/ami06P.m" "")
)
run()
selectResult( 'dc )
plot(getData("/I9/PLUS") getData("/N7/D") getData("/N11/D") )
modelFile(
    '("/project/linuxlab/cadence/CDK/ncsu/models/spectre/nom/ami06N.m" "")
    '("/project/linuxlab/cadence/CDK/ncsu/models/spectre/nom/ami06P.m" "")
)
save( 'i "/P0/D" "/P3/D" )
run()
selectResult( 'dc )
plot(getData("/I9/PLUS") getData("/P0/D") getData("/P3/D") )
modelFile(
    '("/project/linuxlab/cadence/CDK/ncsu/models/spectre/nom/ami06N.m" "")
    '("/project/linuxlab/cadence/CDK/ncsu/models/spectre/nom/ami06P.m" "")
)
run()
selectResult( 'dc )
plot(getData("/I9/PLUS") getData("/P0/D") getData("/P3/D") )
