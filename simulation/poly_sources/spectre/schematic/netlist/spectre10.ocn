simulator( 'spectre )
design(	 "/home/warehouse/lbremer/cadence/simulation/poly_sources/spectre/schematic/netlist/netlist")
resultsDir( "/home/warehouse/lbremer/cadence/simulation/poly_sources/spectre/schematic" )
modelFile(
    '("/project/linuxlab/cadence/CDK/ncsu/models/spectre/nom/ami06N.m" "")
    '("/project/linuxlab/cadence/CDK/ncsu/models/spectre/nom/ami06P.m" "")
)
analysis('dc ?saveOppoint t  ?dev "/I17"  ?param "dc"
		?start "0"  ?stop "5n"  )
envOption(
	'analysisOrder  list("dc")
)
save( 'i "/I17/MINUS" "/N7/S" )
temp( 27 )
run()
selectResult( 'dc )
plot(getData("/I17/MINUS") getData("/N7/S") )
modelFile(
    '("/project/linuxlab/cadence/CDK/ncsu/models/spectre/nom/ami06N.m" "")
    '("/project/linuxlab/cadence/CDK/ncsu/models/spectre/nom/ami06P.m" "")
)
save( 'i "/N0/S" )
run()
selectResult( 'dc )
plot(getData("/I17/MINUS") getData("/N7/S") getData("/N0/S") )
modelFile(
    '("/project/linuxlab/cadence/CDK/ncsu/models/spectre/nom/ami06N.m" "")
    '("/project/linuxlab/cadence/CDK/ncsu/models/spectre/nom/ami06P.m" "")
)
run()
selectResult( 'dc )
plot(getData("/I17/MINUS") getData("/N7/S") getData("/N0/S") )
modelFile(
    '("/project/linuxlab/cadence/CDK/ncsu/models/spectre/nom/ami06N.m" "")
    '("/project/linuxlab/cadence/CDK/ncsu/models/spectre/nom/ami06P.m" "")
)
save( 'i /I17/MINUS )
run()
selectResult( 'dc )
plot(getData("/N0/S") getData("/N7/S") )
modelFile(
    '("/project/linuxlab/cadence/CDK/ncsu/models/spectre/nom/ami06N.m" "")
    '("/project/linuxlab/cadence/CDK/ncsu/models/spectre/nom/ami06P.m" "")
)
analysis('dc ?dev "/I4"  )
run()
selectResult( 'dc )
plot(getData("/N0/S") getData("/N7/S") )
