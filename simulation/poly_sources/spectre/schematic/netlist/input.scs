// Design: cse562/poly_sources
simulator lang=spectre
global 0 vdd!
include "/project/linuxlab/cadence/CDK/ncsu/models/spectre/nom/ami06N.m"
include "/project/linuxlab/cadence/CDK/ncsu/models/spectre/nom/ami06P.m"

// cse562/poly_sources/schematic
I35 (net022 0) isource type=dc dc=1n m=1
I9 (net01 0) isource type=dc dc=10n m=1
I21 (net6 0) isource type=dc dc=1n m=1
N15 (net019 net019 net022 0) ami06N w=900n l=600n m=1 region=sat
N14 (net011 net011 0 0) ami06N w=900n l=600n m=1 region=sat
N13 (net09 net09 net011 0) ami06N w=900n l=600n m=1 region=sat
N12 (net03 net03 net09 0) ami06N w=900n l=600n m=1 region=sat
N11 (vdd! net022 0 0) ami06N w=900n l=600n m=1 region=sat
N10 (vdd! net03 net019 0) ami06N w=900n l=600n m=1 region=sat
N4 (net1 net1 net3 0) ami06N w=900n l=600n m=1 region=sat
N5 (net3 net3 0 0) ami06N w=900n l=600n m=1 region=sat
N6 (vdd! net1 net6 0) ami06N w=900n l=600n m=1 region=sat
N7 (vdd! net6 0 0) ami06N w=900n l=600n m=1 region=sat
V2 (vdd! 0) vsource type=dc dc=3
P3 (net03 net01 vdd! vdd!) ami06P w=900n l=600n m=1 region=sat
P1 (net01 net01 vdd! vdd!) ami06P w=900n l=600n m=1 region=sat
P0 (net1 net01 vdd! vdd!) ami06P w=900n l=600n m=1 region=sat
simulatorOptions options temp=27
dcOp dc
dc dc dev=I9 param=dc start=0 stop=5n
save I9:sink N7:d N11:d P0:d P3:d
