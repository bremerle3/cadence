// Design: cse562/sqrt2
simulator lang=spectre
global 0 vdd!
parameters nW=15u nL=.5u pW=1.5u pL=6u I_o=30n
include "/project/linuxlab/cadence/CDK/ncsu/models/spectre/nom/ami06N.m"
include "/project/linuxlab/cadence/CDK/ncsu/models/spectre/nom/ami06P.m"

// cse562/sqrt2/schematic
V0 (vdd! 0) vsource type=dc dc=1
M3 (vdd! net13 net19 net19) ami06N w=nW l=nL m=1 region=sat
M5 (vdd! net14 net17 net17) ami06N w=nW l=nL m=1 region=sat
M6 (vdd! net13 net14 net14) ami06N w=nW l=nL m=1 region=sat
M7 (net9 net17 0 0) ami06N w=nW l=nL m=1 region=sat
M4 (net14 net17 0 0) ami06N w=nW l=nL m=1 region=sat
M2 (vdd! net19 net3 net3) ami06N w=nW l=nL m=1 region=sat
M1 (net13 net3 0 0) ami06N w=nW l=nL m=1 region=sat
I_5 (net17 0) isource type=dc dc=I_o m=1
I_3 (net19 0) isource type=dc dc=I_o m=1
I_2 (net3 0) isource type=dc dc=I_o m=1
I_1 (vdd! net13) isource type=dc dc=30n m=1
Mb (0 net9 vdd! vdd!) ami06P w=pW l=pL m=1 region=sat
Ma (net9 net9 vdd! vdd!) ami06P w=pW l=pL m=1 region=sat
simulatorOptions options temp=27
dcOp dc
dc dc dev=I_1 param=dc start=0 stop=100n
save Mb:d I_1:sink Ma:d
