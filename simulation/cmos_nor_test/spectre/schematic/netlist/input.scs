// Design: 563_final/cmos_nor_test
simulator lang=spectre
global 0 vdd!
parameters Vin2=0 Vin1=0
include "/project/linuxlab/cadence/CDK/ncsu/models/spectre/nom/ami06N.m"
include "/project/linuxlab/cadence/CDK/ncsu/models/spectre/nom/ami06P.m"

// 563_final/cmos_nor/schematic
subckt cmos_nor Vin1 Vin2 Vout
    N1 (Vout Vin1 net8 0) ami06N w=1.8u l=600n m=1 region=sat
    N0 (net8 Vin2 0 0) ami06N w=1.8u l=600n m=1 region=sat
    P1 (Vout Vin1 vdd! vdd!) ami06P w=1.35u l=600n m=1 region=sat
    P0 (Vout Vin2 vdd! vdd!) ami06P w=1.35u l=600n m=1 region=sat
ends cmos_nor

// 563_final/cmos_nor_test/schematic
I8 (net03 net02 net2) cmos_nor
V3 (net02 0) vsource type=dc dc=Vin2
V1 (net03 0) vsource type=dc dc=Vin1
V0 (vdd! 0) vsource type=dc dc=5
C0 (net2 0) capacitor c=1f m=1
simulatorOptions options temp=27
dcOp dc
dc dc dev=V1 param=dc start=0 stop=5
