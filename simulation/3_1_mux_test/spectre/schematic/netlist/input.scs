// Design: cse463_project/3_1_mux_test
simulator lang=spectre
global 0 vdd!
include "/project/linuxlab/cadence/CDK/ncsu/models/spectre/nom/ami06N.m"
include "/project/linuxlab/cadence/CDK/ncsu/models/spectre/nom/ami06P.m"

// cse463_project/3_1_mux/schematic
subckt cse463_project_3_1_mux_schematic Hold Load Out S0 S1 inh_inh_bn
    M3 (net19 S1 0 gnd!) ami06N w=900n l=600n m=1 region=sat
    M2 (Out S0 net17 gnd!) ami06N w=900n l=600n m=1 region=sat
    M1 (Out S0 net18 gnd!) ami06N w=900n l=600n m=1 region=sat
    M0 (net18 S1 Hold gnd!) ami06N w=900n l=600n m=1 region=sat
    M5 (net19 S0 Out vdd!) ami06P w=900n l=600n m=1 region=sat
    M4 (Load S1 net17 vdd!) ami06P w=900n l=600n m=1 region=sat
ends cse463_project_3_1_mux_schematic

// cse463_project/3_1_mux_test/schematic
I0 (net2 Load net2 S0 S1 0) cse463_project_3_1_mux_schematic
V2 (Load 0) vsource type=pulse val0=5 val1=0 period=200n width=100n
V1 (S0 0) vsource type=pulse val0=0 val1=5 period=600n delay=100n width=300n
V0 (S1 0) vsource type=pulse val0=0 val1=5 period=400n width=200n
V3 (vdd! 0) vsource type=dc dc=5
simulatorOptions options temp=27
tran tran stop=2u
