// Design: cse562/div2
simulator lang=spectre
global 0 vdd!
include "/project/linuxlab/cadence/CDK/ncsu/models/spectre/nom/ami06N.m"
include "/project/linuxlab/cadence/CDK/ncsu/models/spectre/nom/ami06P.m"

// cse562/div2/schematic
P2 (0 net012 vdd! vdd!) ami06P w=900n l=600n m=1 region=sat
P1 (net012 net012 vdd! vdd!) ami06P w=900n l=600n m=1 region=sat
P0 (net01 net014 vdd! vdd!) ami06P w=900n l=600n m=1 region=sat
N2 (vdd! net01 0 0) ami06N w=900n l=600n m=1 region=sat
N1 (net01 net01 0 0) ami06N w=900n l=600n m=1 region=sat
N0 (net01 net01 0 0) ami06N w=900n l=600n m=1 region=sat
V1 (vdd! 0) vsource type=dc dc=3
I29 (net012 0) isource type=dc m=1
simulatorOptions options temp=27
dc dc dev=I29 param=dc start=0 stop=10n
save P1:d I29:sink P2:d
