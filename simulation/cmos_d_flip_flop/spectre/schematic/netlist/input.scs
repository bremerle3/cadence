// Design: cse562/cmos_d_flip_flop
simulator lang=spectre
global 0 vdd!
parameters nW=900n nL=600n pW=900n pL=600n
include "/project/linuxlab/cadence/CDK/ncsu/models/spectre/nom/ami06N.m"
include "/project/linuxlab/cadence/CDK/ncsu/models/spectre/nom/ami06P.m"

// cse562/cmos_d_flip_flop/schematic
N14 (net063 net012 0 0) ami06N w=nW l=nL m=1 region=sat
N13 (0 0 0 0) ami06N w=nW l=nL m=1 region=sat
N12 (0 net21 0 0) ami06N w=nW l=nL m=1 region=sat
N11 (net39 net11 0 0) ami06N w=nW l=nL m=1 region=sat
N10 (net13 0 net39 net39) ami06N w=nW l=nL m=1 region=sat
N9 (net11 net13 0 0) ami06N w=nW l=nL m=1 region=sat
N8 (net35 net1 0 0) ami06N w=nW l=nL m=1 region=sat
N7 (net13 0 net35 net35) ami06N w=nW l=nL m=1 region=sat
N6 (net23 net1 0 0) ami06N w=nW l=nL m=1 region=sat
N5 (net3 0 net23 net23) ami06N w=nW l=nL m=1 region=sat
N4 (net1 net3 0 0) ami06N w=nW l=nL m=1 region=sat
N3 (net18 net16 0 0) ami06N w=nW l=nL m=1 region=sat
N2 (net3 0 net18 net18) ami06N w=nW l=nL m=1 region=sat
P14 (net063 net012 vdd! vdd!) ami06P w=pW l=pL m=1 region=sat
P13 (0 0 vdd! vdd!) ami06P w=pW l=pL m=1 region=sat
P12 (0 net21 vdd! vdd!) ami06P w=pW l=pL m=1 region=sat
P11 (net13 0 net40 net40) ami06P w=pW l=pL m=1 region=sat
P10 (net40 net11 vdd! vdd!) ami06P w=pW l=pL m=1 region=sat
P9 (net11 net13 vdd! vdd!) ami06P w=pW l=pL m=1 region=sat
P8 (net13 0 net36 net36) ami06P w=pW l=pL m=1 region=sat
P7 (net36 net1 vdd! vdd!) ami06P w=pW l=pL m=1 region=sat
P6 (net3 0 net24 net3) ami06P w=pW l=pL m=1 region=sat
P5 (net24 net1 vdd! net24) ami06P w=pW l=pL m=1 region=sat
P4 (net1 net3 vdd! vdd!) ami06P w=pW l=pL m=1 region=sat
P3 (net3 0 net19 net19) ami06P w=pW l=pL m=1 region=sat
P2 (net19 net16 vdd! vdd!) ami06P w=pW l=pL m=1 region=sat
V3 (net012 0) vsource type=pulse val0=0 val1=3 period=4u
V1 (net16 0) vsource type=pulse val0=0 val1=3 period=4u
V0 (net21 0) vsource type=pulse val0=0 val1=3 period=4u
V2 (vdd! 0) vsource type=dc dc=3
simulatorOptions options temp=27
tran tran stop=20u
