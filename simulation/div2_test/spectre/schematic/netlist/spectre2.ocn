simulator( 'spectre )
design(	 "/home/warehouse/lbremer/cadence/simulation/div2_test/spectre/schematic/netlist/netlist")
resultsDir( "/home/warehouse/lbremer/cadence/simulation/div2_test/spectre/schematic" )
modelFile(
    '("/project/linuxlab/cadence/CDK/ncsu/models/spectre/nom/ami06N.m" "")
    '("/project/linuxlab/cadence/CDK/ncsu/models/spectre/nom/ami06P.m" "")
)
analysis('tran ?stop "20n"  )
analysis('dc ?saveOppoint t  ?dev "/V1"  ?param "dc"
		?start "0"  ?stop "1"  )
envOption(
	'analysisOrder  list("dc" "tran")
)
save( 'i "/I0/Out" "/V1/PLUS" )
temp( 27 )
run()
selectResult( 'dc )
plot(getData("/I0/Out") getData("/V1/PLUS") )
selectResult( 'tran )
plot(getData("/I0/Out") getData("/V1/PLUS") )
modelFile(
    '("/project/linuxlab/cadence/CDK/ncsu/models/spectre/nom/ami06N.m" "")
    '("/project/linuxlab/cadence/CDK/ncsu/models/spectre/nom/ami06P.m" "")
)
run()
selectResult( 'dc )
plot(getData("/I0/Out") getData("/V1/PLUS") )
selectResult( 'tran )
plot(getData("/I0/Out") getData("/V1/PLUS") )
modelFile(
    '("/project/linuxlab/cadence/CDK/ncsu/models/spectre/nom/ami06N.m" "")
    '("/project/linuxlab/cadence/CDK/ncsu/models/spectre/nom/ami06P.m" "")
)
run()
selectResult( 'dc )
plot(getData("/I0/Out") getData("/V1/PLUS") )
selectResult( 'tran )
plot(getData("/I0/Out") getData("/V1/PLUS") )
modelFile(
    '("/project/linuxlab/cadence/CDK/ncsu/models/spectre/nom/ami06N.m" "")
    '("/project/linuxlab/cadence/CDK/ncsu/models/spectre/nom/ami06P.m" "")
)
run()
selectResult( 'dc )
plot(getData("/I0/Out") getData("/V1/PLUS") )
selectResult( 'tran )
plot(getData("/I0/Out") getData("/V1/PLUS") )
modelFile(
    '("/project/linuxlab/cadence/CDK/ncsu/models/spectre/nom/ami06N.m" "")
    '("/project/linuxlab/cadence/CDK/ncsu/models/spectre/nom/ami06P.m" "")
)
run()
selectResult( 'dc )
plot(getData("/I0/Out") getData("/V1/PLUS") )
selectResult( 'tran )
plot(getData("/I0/Out") getData("/V1/PLUS") )
modelFile(
    '("/project/linuxlab/cadence/CDK/ncsu/models/spectre/nom/ami06N.m" "")
    '("/project/linuxlab/cadence/CDK/ncsu/models/spectre/nom/ami06P.m" "")
)
run()
selectResult( 'dc )
plot(getData("/I0/Out") getData("/V1/PLUS") )
selectResult( 'tran )
plot(getData("/I0/Out") getData("/V1/PLUS") )
modelFile(
    '("/project/linuxlab/cadence/CDK/ncsu/models/spectre/nom/ami06N.m" "")
    '("/project/linuxlab/cadence/CDK/ncsu/models/spectre/nom/ami06P.m" "")
)
save( 'i "/I0/In" )
save( 'i /V1/PLUS )
run()
selectResult( 'dc )
plot(getData("/I0/Out") getData("/I0/In") )
selectResult( 'tran )
plot(getData("/I0/Out") getData("/I0/In") )
modelFile(
    '("/project/linuxlab/cadence/CDK/ncsu/models/spectre/nom/ami06N.m" "")
    '("/project/linuxlab/cadence/CDK/ncsu/models/spectre/nom/ami06P.m" "")
)
run()
selectResult( 'dc )
plot(getData("/I0/Out") getData("/I0/In") )
selectResult( 'tran )
plot(getData("/I0/Out") getData("/I0/In") )
modelFile(
    '("/project/linuxlab/cadence/CDK/ncsu/models/spectre/nom/ami06N.m" "")
    '("/project/linuxlab/cadence/CDK/ncsu/models/spectre/nom/ami06P.m" "")
)
delete( 'desVar "na" )
run()
selectResult( 'dc )
plot(getData("/I0/Out") getData("/I0/In") )
selectResult( 'tran )
plot(getData("/I0/Out") getData("/I0/In") )
