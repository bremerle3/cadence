// Design: cse562/div2_test
simulator lang=spectre
global 0 vdd!
include "/project/linuxlab/cadence/CDK/ncsu/models/spectre/nom/ami06N.m"
include "/project/linuxlab/cadence/CDK/ncsu/models/spectre/nom/ami06P.m"

// cse562/div2/schematic
subckt div2 In Out
    N2 (Out net4 0 0) ami06N w=900n l=600n m=1 region=sat
    N1 (In net4 0 0) ami06N w=900n l=600n m=1 region=sat
    N0 (In net4 0 0) ami06N w=900n l=600n m=1 region=sat
ends div2

// cse562/div2_test/schematic
I6 (net1 net05) div2
V0 (vdd! 0) vsource type=dc dc=3
I4 (net1 0) isource type=dc dc=500.0u m=1
simulatorOptions options temp=27
dcOp dc
dc dc dev=I4 param=dc start=0 stop=1
save I6:1 I6:2
