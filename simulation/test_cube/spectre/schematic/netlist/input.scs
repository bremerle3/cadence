// Design: cse562/test_cube
simulator lang=spectre
global 0 vdd!
parameters pW=2.4u pL=2u nW=2.4u nL=2u
include "/project/linuxlab/cadence/CDK/ncsu/models/spectre/nom/ami06N.m"
include "/project/linuxlab/cadence/CDK/ncsu/models/spectre/nom/ami06P.m"

// cse562/squarer/schematic
subckt squarer I_In I_Out I_o Squared
    M4 (0 I_Out I_o vdd!) ami06P w=pW l=pL m=1 region=sat
    M1 (0 I_Out I_In vdd!) ami06P w=pW l=pL m=1 region=sat
    M3 (Squared I_o vdd! vdd!) ami06P w=pW l=pL m=1 region=sat
    M2 (I_Out I_In vdd! vdd!) ami06P w=pW l=pL m=1 region=sat
ends squarer

// cse562/test_cube/schematic
P22 (net037 net013 vdd! vdd!) ami06P w=pW l=2*pL m=1 region=sat
P21 (net037 net013 vdd! vdd!) ami06P w=pW l=2*pL m=1 region=sat
P15 (net040 net4 vdd! vdd!) ami06P w=pW l=2*pL m=1 region=sat
P14 (net037 net013 vdd! vdd!) ami06P w=pW l=2*pL m=1 region=sat
P11 (net023 net013 vdd! vdd!) ami06P w=pW l=pL*(1) m=1 region=sat
P10 (net013 net013 vdd! vdd!) ami06P w=pW l=pL m=1 region=sat
P5 (net017 net6 vdd! vdd!) ami06P w=pW l=pL m=1 region=sat
P3 (net6 net6 vdd! vdd!) ami06P w=pW l=pL m=1 region=sat
P2 (net12 net6 vdd! vdd!) ami06P w=pW l=pL m=1 region=sat
P0 (net4 net4 vdd! vdd!) ami06P w=pW l=pL m=1 region=sat
P1 (net18 net4 vdd! vdd!) ami06P w=pW l=pL m=1 region=sat
Input (0 net1) isource type=dc m=1
Bias (net6 0) isource type=dc dc=60n m=1
N15 (net040 net037 0 0) ami06N w=nW l=nL m=1 region=sat
N12 (net037 net037 0 0) ami06N w=nW l=nL m=1 region=sat
N6 (net013 net030 0 0) ami06N w=nW l=nL m=1 region=sat
N5 (net030 net030 0 0) ami06N w=nW l=nL m=1 region=sat
N3 (net018 net1 0 0) ami06N w=nW l=nL m=1 region=sat
N1 (net4 net1 0 0) ami06N w=nW l=nL m=1 region=sat
N2 (net9 net1 0 0) ami06N w=nW l=nL m=1 region=sat
N0 (net1 net1 0 0) ami06N w=nW l=nL m=1 region=sat
V0 (vdd! 0) vsource type=dc dc=3
I8 (net023 net018 net017 net040) squarer
I13 (net18 net9 net12 net030) squarer
simulatorOptions options temp=27
dcOp dc
dc dc dev=Input param=dc start=0 stop=60n
save P15:d N15:d I8:4
