simulator( 'spectre )
design(	 "/home/warehouse/lbremer/cadence/simulation/test_cube/spectre/schematic/netlist/netlist")
resultsDir( "/home/warehouse/lbremer/cadence/simulation/test_cube/spectre/schematic" )
modelFile(
    '("/project/linuxlab/cadence/CDK/ncsu/models/spectre/nom/ami06N.m" "")
    '("/project/linuxlab/cadence/CDK/ncsu/models/spectre/nom/ami06P.m" "")
)
analysis('dc ?saveOppoint t  ?dev "/Input"  ?param "dc"
		?start "0"  ?stop "60n"  )
envOption(
	'analysisOrder  list("dc")
)
save( 'i "/I13/Squared" "/P10/D" "/P11/D" "/P14/D" )
temp( 27 )
run()
selectResult( 'dc )
plot(getData("/I13/Squared") getData("/P10/D") getData("/P11/D") getData("/P14/D") )
modelFile(
    '("/project/linuxlab/cadence/CDK/ncsu/models/spectre/nom/ami06N.m" "")
    '("/project/linuxlab/cadence/CDK/ncsu/models/spectre/nom/ami06P.m" "")
)
desVar(	  "nL" 2u	)
desVar(	  "nW" 2.4u	)
desVar(	  "pL" 2u	)
desVar(	  "pW" 2.4u	)
run()
selectResult( 'dc )
plot(getData("/I13/Squared") getData("/P10/D") getData("/P11/D") getData("/P14/D") )
modelFile(
    '("/project/linuxlab/cadence/CDK/ncsu/models/spectre/nom/ami06N.m" "")
    '("/project/linuxlab/cadence/CDK/ncsu/models/spectre/nom/ami06P.m" "")
)
run()
selectResult( 'dc )
plot(getData("/I13/Squared") getData("/P10/D") getData("/P11/D") getData("/P14/D") )
modelFile(
    '("/project/linuxlab/cadence/CDK/ncsu/models/spectre/nom/ami06N.m" "")
    '("/project/linuxlab/cadence/CDK/ncsu/models/spectre/nom/ami06P.m" "")
)
run()
selectResult( 'dc )
plot(getData("/I13/Squared") getData("/P10/D") getData("/P11/D") getData("/P14/D") )
modelFile(
    '("/project/linuxlab/cadence/CDK/ncsu/models/spectre/nom/ami06N.m" "")
    '("/project/linuxlab/cadence/CDK/ncsu/models/spectre/nom/ami06P.m" "")
)
run()
selectResult( 'dc )
plot(getData("/I13/Squared") getData("/P10/D") getData("/P11/D") getData("/P14/D") )
modelFile(
    '("/project/linuxlab/cadence/CDK/ncsu/models/spectre/nom/ami06N.m" "")
    '("/project/linuxlab/cadence/CDK/ncsu/models/spectre/nom/ami06P.m" "")
)
run()
selectResult( 'dc )
plot(getData("/I13/Squared") getData("/P10/D") getData("/P11/D") getData("/P14/D") )
modelFile(
    '("/project/linuxlab/cadence/CDK/ncsu/models/spectre/nom/ami06N.m" "")
    '("/project/linuxlab/cadence/CDK/ncsu/models/spectre/nom/ami06P.m" "")
)
run()
selectResult( 'dc )
plot(getData("/I13/Squared") getData("/P10/D") getData("/P11/D") getData("/P14/D") )
modelFile(
    '("/project/linuxlab/cadence/CDK/ncsu/models/spectre/nom/ami06N.m" "")
    '("/project/linuxlab/cadence/CDK/ncsu/models/spectre/nom/ami06P.m" "")
)
run()
selectResult( 'dc )
plot(getData("/I13/Squared") getData("/P10/D") getData("/P11/D") getData("/P14/D") )
modelFile(
    '("/project/linuxlab/cadence/CDK/ncsu/models/spectre/nom/ami06N.m" "")
    '("/project/linuxlab/cadence/CDK/ncsu/models/spectre/nom/ami06P.m" "")
)
save( 'i "/N0/D" "/P15/D" )
run()
selectResult( 'dc )
plot(getData("/N0/D") getData("/P15/D") )
modelFile(
    '("/project/linuxlab/cadence/CDK/ncsu/models/spectre/nom/ami06N.m" "")
    '("/project/linuxlab/cadence/CDK/ncsu/models/spectre/nom/ami06P.m" "")
)
save( 'i "/N1/D" )
run()
selectResult( 'dc )
plot(getData("/N0/D") getData("/P15/D") getData("/N1/D") )
modelFile(
    '("/project/linuxlab/cadence/CDK/ncsu/models/spectre/nom/ami06N.m" "")
    '("/project/linuxlab/cadence/CDK/ncsu/models/spectre/nom/ami06P.m" "")
)
run()
selectResult( 'dc )
plot(getData("/N0/D") getData("/P15/D") getData("/N1/D") )
modelFile(
    '("/project/linuxlab/cadence/CDK/ncsu/models/spectre/nom/ami06N.m" "")
    '("/project/linuxlab/cadence/CDK/ncsu/models/spectre/nom/ami06P.m" "")
)
save( 'i "/I8/Squared" )
run()
selectResult( 'dc )
plot(getData("/P14/D") getData("/P15/D") getData("/I8/Squared") )
modelFile(
    '("/project/linuxlab/cadence/CDK/ncsu/models/spectre/nom/ami06N.m" "")
    '("/project/linuxlab/cadence/CDK/ncsu/models/spectre/nom/ami06P.m" "")
)
save( 'i "/N10/D" )
save( 'i /I13/Squared /P10/D /P11/D /N0/D /P15/D /N1/D /I8/Squared )
run()
selectResult( 'dc )
plot(getData("/P14/D") getData("/N10/D") )
modelFile(
    '("/project/linuxlab/cadence/CDK/ncsu/models/spectre/nom/ami06N.m" "")
    '("/project/linuxlab/cadence/CDK/ncsu/models/spectre/nom/ami06P.m" "")
)
save( 'i "/N15/D" )
save( 'i /N10/D )
run()
selectResult( 'dc )
plot(getData("/P14/D") getData("/N15/D") )
modelFile(
    '("/project/linuxlab/cadence/CDK/ncsu/models/spectre/nom/ami06N.m" "")
    '("/project/linuxlab/cadence/CDK/ncsu/models/spectre/nom/ami06P.m" "")
)
save( 'i "/P15/D" "/I8/Squared" )
save( 'i /P14/D )
run()
selectResult( 'dc )
plot(getData("/P15/D") getData("/I8/Squared") getData("/N15/D") )
modelFile(
    '("/project/linuxlab/cadence/CDK/ncsu/models/spectre/nom/ami06N.m" "")
    '("/project/linuxlab/cadence/CDK/ncsu/models/spectre/nom/ami06P.m" "")
)
save( 'i "/P14/D" )
save( 'i /N15/D )
run()
selectResult( 'dc )
plot(getData("/I8/Squared") getData("/P15/D") getData("/P14/D") )
modelFile(
    '("/project/linuxlab/cadence/CDK/ncsu/models/spectre/nom/ami06N.m" "")
    '("/project/linuxlab/cadence/CDK/ncsu/models/spectre/nom/ami06P.m" "")
)
save( 'i "/I25/gnd!" )
run()
selectResult( 'dc )
plot(getData("/I8/Squared") getData("/P15/D") getData("/P14/D") getData("/I25/gnd!") )
modelFile(
    '("/project/linuxlab/cadence/CDK/ncsu/models/spectre/nom/ami06N.m" "")
    '("/project/linuxlab/cadence/CDK/ncsu/models/spectre/nom/ami06P.m" "")
)
save( 'i "/P17/D" )
save( 'i /P14/D /I25/gnd! )
run()
selectResult( 'dc )
plot(getData("/P15/D") getData("/I8/Squared") getData("/P17/D") )
modelFile(
    '("/project/linuxlab/cadence/CDK/ncsu/models/spectre/nom/ami06N.m" "")
    '("/project/linuxlab/cadence/CDK/ncsu/models/spectre/nom/ami06P.m" "")
)
save( 'i "/P14/D" )
save( 'i /P17/D )
run()
selectResult( 'dc )
plot(getData("/P15/D") getData("/I8/Squared") getData("/P14/D") )
modelFile(
    '("/project/linuxlab/cadence/CDK/ncsu/models/spectre/nom/ami06N.m" "")
    '("/project/linuxlab/cadence/CDK/ncsu/models/spectre/nom/ami06P.m" "")
)
save( 'i "/I9/gnd!" )
run()
selectResult( 'dc )
plot(getData("/P15/D") getData("/I8/Squared") getData("/P14/D") getData("/I9/gnd!") )
modelFile(
    '("/project/linuxlab/cadence/CDK/ncsu/models/spectre/nom/ami06N.m" "")
    '("/project/linuxlab/cadence/CDK/ncsu/models/spectre/nom/ami06P.m" "")
)
save( 'i "/N15/D" )
save( 'i /P14/D /I9/gnd! )
run()
selectResult( 'dc )
plot(getData("/P15/D") getData("/I8/Squared") getData("/N15/D") )
modelFile(
    '("/project/linuxlab/cadence/CDK/ncsu/models/spectre/nom/ami06N.m" "")
    '("/project/linuxlab/cadence/CDK/ncsu/models/spectre/nom/ami06P.m" "")
)
save( 'i "/I26/gnd!" )
save( 'i /N15/D )
run()
selectResult( 'dc )
plot(getData("/P15/D") getData("/I8/Squared") getData("/I26/gnd!") )
modelFile(
    '("/project/linuxlab/cadence/CDK/ncsu/models/spectre/nom/ami06N.m" "")
    '("/project/linuxlab/cadence/CDK/ncsu/models/spectre/nom/ami06P.m" "")
)
save( 'i "/N15/D" "/N12/D" )
run()
selectResult( 'dc )
plot(getData("/P15/D") getData("/I8/Squared") getData("/I26/gnd!") getData("/N15/D") getData("/N12/D") )
modelFile(
    '("/project/linuxlab/cadence/CDK/ncsu/models/spectre/nom/ami06N.m" "")
    '("/project/linuxlab/cadence/CDK/ncsu/models/spectre/nom/ami06P.m" "")
)
save( 'i "/P18/S" )
save( 'i /I26/gnd! /N15/D /N12/D )
run()
selectResult( 'dc )
plot(getData("/P15/D") getData("/I8/Squared") getData("/P18/S") )
modelFile(
    '("/project/linuxlab/cadence/CDK/ncsu/models/spectre/nom/ami06N.m" "")
    '("/project/linuxlab/cadence/CDK/ncsu/models/spectre/nom/ami06P.m" "")
)
save( 'i "/N15/D" "/N16/D" )
save( 'i /P18/S )
run()
selectResult( 'dc )
plot(getData("/P15/D") getData("/I8/Squared") getData("/N15/D") getData("/N16/D") )
modelFile(
    '("/project/linuxlab/cadence/CDK/ncsu/models/spectre/nom/ami06N.m" "")
    '("/project/linuxlab/cadence/CDK/ncsu/models/spectre/nom/ami06P.m" "")
)
run()
selectResult( 'dc )
plot(getData("/N15/D") getData("/I8/Squared") getData("/P15/D") getData("/N16/D") )
modelFile(
    '("/project/linuxlab/cadence/CDK/ncsu/models/spectre/nom/ami06N.m" "")
    '("/project/linuxlab/cadence/CDK/ncsu/models/spectre/nom/ami06P.m" "")
)
save( 'i "/N12/D" "/P14/D" )
save( 'i /I8/Squared /P15/D /N16/D )
run()
selectResult( 'dc )
plot(getData("/N12/D") getData("/N15/D") getData("/P14/D") )
modelFile(
    '("/project/linuxlab/cadence/CDK/ncsu/models/spectre/nom/ami06N.m" "")
    '("/project/linuxlab/cadence/CDK/ncsu/models/spectre/nom/ami06P.m" "")
)
save( 'i "/P15/D" "/I8/Squared" "/N16/D" )
save( 'i /N12/D /N15/D )
run()
selectResult( 'dc )
plot(getData("/P15/D") getData("/I8/Squared") getData("/P14/D") getData("/N16/D") )
modelFile(
    '("/project/linuxlab/cadence/CDK/ncsu/models/spectre/nom/ami06N.m" "")
    '("/project/linuxlab/cadence/CDK/ncsu/models/spectre/nom/ami06P.m" "")
)
save( 'i "/P19/D" "/N12/D" )
run()
selectResult( 'dc )
plot(getData("/P15/D") getData("/I8/Squared") getData("/P14/D") getData("/N16/D") getData("/P19/D") getData("/N12/D") )
modelFile(
    '("/project/linuxlab/cadence/CDK/ncsu/models/spectre/nom/ami06N.m" "")
    '("/project/linuxlab/cadence/CDK/ncsu/models/spectre/nom/ami06P.m" "")
)
save( 'i "/N15/D" )
save( 'i /P14/D /P19/D /N12/D )
run()
selectResult( 'dc )
plot(getData("/P15/D") getData("/I8/Squared") getData("/N15/D") getData("/N16/D") )
modelFile(
    '("/project/linuxlab/cadence/CDK/ncsu/models/spectre/nom/ami06N.m" "")
    '("/project/linuxlab/cadence/CDK/ncsu/models/spectre/nom/ami06P.m" "")
)
run()
selectResult( 'dc )
plot(getData("/P15/D") getData("/I8/Squared") getData("/N15/D") getData("/N16/D") )
modelFile(
    '("/project/linuxlab/cadence/CDK/ncsu/models/spectre/nom/ami06N.m" "")
    '("/project/linuxlab/cadence/CDK/ncsu/models/spectre/nom/ami06P.m" "")
)
run()
selectResult( 'dc )
plot(getData("/N16/D") )
modelFile(
    '("/project/linuxlab/cadence/CDK/ncsu/models/spectre/nom/ami06N.m" "")
    '("/project/linuxlab/cadence/CDK/ncsu/models/spectre/nom/ami06P.m" "")
)
desVar(	  "nL" 4u	)
desVar(	  "nW" 4u	)
desVar(	  "pL" 4u	)
desVar(	  "pW" 4u	)
run()
selectResult( 'dc )
plot(getData("/N16/D") )
modelFile(
    '("/project/linuxlab/cadence/CDK/ncsu/models/spectre/nom/ami06N.m" "")
    '("/project/linuxlab/cadence/CDK/ncsu/models/spectre/nom/ami06P.m" "")
)
analysis('dc ?stop "30n"  )
run()
selectResult( 'dc )
plot(getData("/N16/D") )
modelFile(
    '("/project/linuxlab/cadence/CDK/ncsu/models/spectre/nom/ami06N.m" "")
    '("/project/linuxlab/cadence/CDK/ncsu/models/spectre/nom/ami06P.m" "")
)
run()
selectResult( 'dc )
plot(getData("/N16/D") )
modelFile(
    '("/project/linuxlab/cadence/CDK/ncsu/models/spectre/nom/ami06N.m" "")
    '("/project/linuxlab/cadence/CDK/ncsu/models/spectre/nom/ami06P.m" "")
)
analysis('dc ?stop "60n"  )
desVar(	  "nL" 2u	)
desVar(	  "nW" 2u	)
desVar(	  "pL" 2u	)
desVar(	  "pW" 2u	)
run()
selectResult( 'dc )
plot(getData("/N16/D") )
modelFile(
    '("/project/linuxlab/cadence/CDK/ncsu/models/spectre/nom/ami06N.m" "")
    '("/project/linuxlab/cadence/CDK/ncsu/models/spectre/nom/ami06P.m" "")
)
desVar(	  "nW" 2.4u	)
desVar(	  "pW" 2.4u	)
run()
selectResult( 'dc )
plot(getData("/N16/D") )
modelFile(
    '("/project/linuxlab/cadence/CDK/ncsu/models/spectre/nom/ami06N.m" "")
    '("/project/linuxlab/cadence/CDK/ncsu/models/spectre/nom/ami06P.m" "")
)
run()
selectResult( 'dc )
plot(getData("/N16/D") )
modelFile(
    '("/project/linuxlab/cadence/CDK/ncsu/models/spectre/nom/ami06N.m" "")
    '("/project/linuxlab/cadence/CDK/ncsu/models/spectre/nom/ami06P.m" "")
)
run()
selectResult( 'dc )
plot(getData("/N16/D") )
modelFile(
    '("/project/linuxlab/cadence/CDK/ncsu/models/spectre/nom/ami06N.m" "")
    '("/project/linuxlab/cadence/CDK/ncsu/models/spectre/nom/ami06P.m" "")
)
save( 'i "/I13/Squared" "/I8/I_In" )
save( 'i /P15/D /I8/Squared /N15/D /N16/D )
run()
selectResult( 'dc )
plot(getData("/I13/Squared") getData("/I8/I_In") )
modelFile(
    '("/project/linuxlab/cadence/CDK/ncsu/models/spectre/nom/ami06N.m" "")
    '("/project/linuxlab/cadence/CDK/ncsu/models/spectre/nom/ami06P.m" "")
)
save( 'i "/N5/D" "/N6/D" "/P10/D" "/P11/D" )
run()
selectResult( 'dc )
plot(getData("/I13/Squared") getData("/I8/I_In") getData("/N5/D") getData("/N6/D") getData("/P10/D") getData("/P11/D") )
modelFile(
    '("/project/linuxlab/cadence/CDK/ncsu/models/spectre/nom/ami06N.m" "")
    '("/project/linuxlab/cadence/CDK/ncsu/models/spectre/nom/ami06P.m" "")
)
save( 'i /I13/Squared /I8/I_In /N5/D /N6/D /P10/D /P11/D )
run()
modelFile(
    '("/project/linuxlab/cadence/CDK/ncsu/models/spectre/nom/ami06N.m" "")
    '("/project/linuxlab/cadence/CDK/ncsu/models/spectre/nom/ami06P.m" "")
)
run()
modelFile(
    '("/project/linuxlab/cadence/CDK/ncsu/models/spectre/nom/ami06N.m" "")
    '("/project/linuxlab/cadence/CDK/ncsu/models/spectre/nom/ami06P.m" "")
)
run()
modelFile(
    '("/project/linuxlab/cadence/CDK/ncsu/models/spectre/nom/ami06N.m" "")
    '("/project/linuxlab/cadence/CDK/ncsu/models/spectre/nom/ami06P.m" "")
)
run()
modelFile(
    '("/project/linuxlab/cadence/CDK/ncsu/models/spectre/nom/ami06N.m" "")
    '("/project/linuxlab/cadence/CDK/ncsu/models/spectre/nom/ami06P.m" "")
)
save( 'i "/I13/Squared" "/N5/D" "/N6/D" "/P10/D" "/P11/D" )
run()
selectResult( 'dc )
plot(getData("/I13/Squared") getData("/N5/D") getData("/N6/D") getData("/P10/D") getData("/P11/D") )
modelFile(
    '("/project/linuxlab/cadence/CDK/ncsu/models/spectre/nom/ami06N.m" "")
    '("/project/linuxlab/cadence/CDK/ncsu/models/spectre/nom/ami06P.m" "")
)
run()
selectResult( 'dc )
plot(getData("/I13/Squared") getData("/N5/D") getData("/N6/D") getData("/P10/D") getData("/P11/D") )
modelFile(
    '("/project/linuxlab/cadence/CDK/ncsu/models/spectre/nom/ami06N.m" "")
    '("/project/linuxlab/cadence/CDK/ncsu/models/spectre/nom/ami06P.m" "")
)
save( 'i "/P15/D" "/I8/Squared" "/N15/D" "/N16/D" )
save( 'i /I13/Squared /N5/D /N6/D /P10/D /P11/D )
run()
selectResult( 'dc )
plot(getData("/P15/D") getData("/I8/Squared") getData("/N15/D") getData("/N16/D") )
modelFile(
    '("/project/linuxlab/cadence/CDK/ncsu/models/spectre/nom/ami06N.m" "")
    '("/project/linuxlab/cadence/CDK/ncsu/models/spectre/nom/ami06P.m" "")
)
run()
selectResult( 'dc )
plot(getData("/N16/D") )
modelFile(
    '("/project/linuxlab/cadence/CDK/ncsu/models/spectre/nom/ami06N.m" "")
    '("/project/linuxlab/cadence/CDK/ncsu/models/spectre/nom/ami06P.m" "")
)
run()
selectResult( 'dc )
plot(getData("/N16/D") )
modelFile(
    '("/project/linuxlab/cadence/CDK/ncsu/models/spectre/nom/ami06N.m" "")
    '("/project/linuxlab/cadence/CDK/ncsu/models/spectre/nom/ami06P.m" "")
)
run()
selectResult( 'dc )
plot(getData("/N16/D") )
modelFile(
    '("/project/linuxlab/cadence/CDK/ncsu/models/spectre/nom/ami06N.m" "")
    '("/project/linuxlab/cadence/CDK/ncsu/models/spectre/nom/ami06P.m" "")
)
save( 'i "/N12/D" )
run()
selectResult( 'dc )
plot(getData("/P15/D") getData("/I8/Squared") getData("/N15/D") getData("/N12/D") )
modelFile(
    '("/project/linuxlab/cadence/CDK/ncsu/models/spectre/nom/ami06N.m" "")
    '("/project/linuxlab/cadence/CDK/ncsu/models/spectre/nom/ami06P.m" "")
)
run()
selectResult( 'dc )
plot(getData("/N16/D") )
modelFile(
    '("/project/linuxlab/cadence/CDK/ncsu/models/spectre/nom/ami06N.m" "")
    '("/project/linuxlab/cadence/CDK/ncsu/models/spectre/nom/ami06P.m" "")
)
save( 'i "/P11/D" "/I8/I_Out" "/I13/I_Out" )
run()
selectResult( 'dc )
plot(getData("/P11/D") getData("/I8/I_Out") getData("/I13/I_Out") )
modelFile(
    '("/project/linuxlab/cadence/CDK/ncsu/models/spectre/nom/ami06N.m" "")
    '("/project/linuxlab/cadence/CDK/ncsu/models/spectre/nom/ami06P.m" "")
)
save( 'i "/P10/D" "/I13/Squared" )
run()
selectResult( 'dc )
plot(getData("/P11/D") getData("/I8/I_Out") getData("/I13/I_Out") getData("/P10/D") getData("/I13/Squared") )
modelFile(
    '("/project/linuxlab/cadence/CDK/ncsu/models/spectre/nom/ami06N.m" "")
    '("/project/linuxlab/cadence/CDK/ncsu/models/spectre/nom/ami06P.m" "")
)
save( 'i "/P14/D" "/P21/D" "/P22/D" )
save( 'i /P15/D /I8/Squared /N15/D /N16/D /N12/D /P11/D /I8/I_Out /I13/I_Out /P10/D /I13/Squared )
run()
selectResult( 'dc )
plot(getData("/P14/D") getData("/P21/D") getData("/P22/D") )
modelFile(
    '("/project/linuxlab/cadence/CDK/ncsu/models/spectre/nom/ami06N.m" "")
    '("/project/linuxlab/cadence/CDK/ncsu/models/spectre/nom/ami06P.m" "")
)
run()
selectResult( 'dc )
plot(getData("/P14/D") getData("/P21/D") getData("/P22/D") )
modelFile(
    '("/project/linuxlab/cadence/CDK/ncsu/models/spectre/nom/ami06N.m" "")
    '("/project/linuxlab/cadence/CDK/ncsu/models/spectre/nom/ami06P.m" "")
)
run()
selectResult( 'dc )
plot(getData("/P14/D") getData("/P21/D") getData("/P22/D") )
modelFile(
    '("/project/linuxlab/cadence/CDK/ncsu/models/spectre/nom/ami06N.m" "")
    '("/project/linuxlab/cadence/CDK/ncsu/models/spectre/nom/ami06P.m" "")
)
run()
selectResult( 'dc )
plot(getData("/P14/D") getData("/P21/D") getData("/P22/D") )
modelFile(
    '("/project/linuxlab/cadence/CDK/ncsu/models/spectre/nom/ami06N.m" "")
    '("/project/linuxlab/cadence/CDK/ncsu/models/spectre/nom/ami06P.m" "")
)
save( 'i "/P11/D" "/P10/D" "/I13/Squared" "/I8/I_In" )
run()
selectResult( 'dc )
plot(getData("/P14/D") getData("/P21/D") getData("/P22/D") getData("/P11/D") getData("/P10/D") getData("/I13/Squared") getData("/I8/I_In") )
modelFile(
    '("/project/linuxlab/cadence/CDK/ncsu/models/spectre/nom/ami06N.m" "")
    '("/project/linuxlab/cadence/CDK/ncsu/models/spectre/nom/ami06P.m" "")
)
run()
selectResult( 'dc )
plot(getData("/P14/D") getData("/P21/D") getData("/P22/D") getData("/P11/D") getData("/P10/D") getData("/I13/Squared") getData("/I8/I_In") )
modelFile(
    '("/project/linuxlab/cadence/CDK/ncsu/models/spectre/nom/ami06N.m" "")
    '("/project/linuxlab/cadence/CDK/ncsu/models/spectre/nom/ami06P.m" "")
)
run()
selectResult( 'dc )
plot(getData("/P14/D") getData("/P21/D") getData("/P22/D") getData("/P11/D") getData("/P10/D") getData("/I13/Squared") getData("/I8/I_In") )
modelFile(
    '("/project/linuxlab/cadence/CDK/ncsu/models/spectre/nom/ami06N.m" "")
    '("/project/linuxlab/cadence/CDK/ncsu/models/spectre/nom/ami06P.m" "")
)
run()
selectResult( 'dc )
plot(getData("/P14/D") getData("/P21/D") getData("/P22/D") getData("/P11/D") getData("/P10/D") getData("/I13/Squared") getData("/I8/I_In") )
modelFile(
    '("/project/linuxlab/cadence/CDK/ncsu/models/spectre/nom/ami06N.m" "")
    '("/project/linuxlab/cadence/CDK/ncsu/models/spectre/nom/ami06P.m" "")
)
run()
selectResult( 'dc )
plot(getData("/P14/D") getData("/P21/D") getData("/P22/D") getData("/P11/D") getData("/P10/D") getData("/I13/Squared") getData("/I8/I_In") )
modelFile(
    '("/project/linuxlab/cadence/CDK/ncsu/models/spectre/nom/ami06N.m" "")
    '("/project/linuxlab/cadence/CDK/ncsu/models/spectre/nom/ami06P.m" "")
)
save( 'i "/N16/D" )
run()
selectResult( 'dc )
plot(getData("/N16/D") )
modelFile(
    '("/project/linuxlab/cadence/CDK/ncsu/models/spectre/nom/ami06N.m" "")
    '("/project/linuxlab/cadence/CDK/ncsu/models/spectre/nom/ami06P.m" "")
)
save( 'i "/N15/D" "/I8/Squared" "/P15/D" )
save( 'i /P14/D /P21/D /P22/D /P11/D /P10/D /I13/Squared /I8/I_In )
run()
selectResult( 'dc )
plot(getData("/N16/D") getData("/N15/D") getData("/I8/Squared") getData("/P15/D") )
modelFile(
    '("/project/linuxlab/cadence/CDK/ncsu/models/spectre/nom/ami06N.m" "")
    '("/project/linuxlab/cadence/CDK/ncsu/models/spectre/nom/ami06P.m" "")
)
save( 'i "/R0/PLUS" )
save( 'i /N16/D /N15/D /I8/Squared /P15/D )
run()
selectResult( 'dc )
plot(getData("/R0/PLUS") )
modelFile(
    '("/project/linuxlab/cadence/CDK/ncsu/models/spectre/nom/ami06N.m" "")
    '("/project/linuxlab/cadence/CDK/ncsu/models/spectre/nom/ami06P.m" "")
)
save( 'i /R0/PLUS )
run()
modelFile(
    '("/project/linuxlab/cadence/CDK/ncsu/models/spectre/nom/ami06N.m" "")
    '("/project/linuxlab/cadence/CDK/ncsu/models/spectre/nom/ami06P.m" "")
)
save( 'i "/N17/D" "/P23/S" )
run()
selectResult( 'dc )
plot(getData("/N17/D") getData("/P23/S") )
modelFile(
    '("/project/linuxlab/cadence/CDK/ncsu/models/spectre/nom/ami06N.m" "")
    '("/project/linuxlab/cadence/CDK/ncsu/models/spectre/nom/ami06P.m" "")
)
save( 'i "/P15/D" "/I8/Squared" "/N15/D" )
save( 'i /N17/D /P23/S )
run()
selectResult( 'dc )
plot(getData("/P15/D") getData("/I8/Squared") getData("/N15/D") )
modelFile(
    '("/project/linuxlab/cadence/CDK/ncsu/models/spectre/nom/ami06N.m" "")
    '("/project/linuxlab/cadence/CDK/ncsu/models/spectre/nom/ami06P.m" "")
)
run()
modelFile(
    '("/project/linuxlab/cadence/CDK/ncsu/models/spectre/nom/ami06N.m" "")
    '("/project/linuxlab/cadence/CDK/ncsu/models/spectre/nom/ami06P.m" "")
)
run()
modelFile(
    '("/project/linuxlab/cadence/CDK/ncsu/models/spectre/nom/ami06N.m" "")
    '("/project/linuxlab/cadence/CDK/ncsu/models/spectre/nom/ami06P.m" "")
)
save( 'i "/P25/S" )
run()
selectResult( 'dc )
plot(getData("/P25/S") )
modelFile(
    '("/project/linuxlab/cadence/CDK/ncsu/models/spectre/nom/ami06N.m" "")
    '("/project/linuxlab/cadence/CDK/ncsu/models/spectre/nom/ami06P.m" "")
)
save( 'i /P25/S )
run()
selectResult( 'dc )
plot(getData("/P15/D") getData("/I8/Squared") getData("/N15/D") )
modelFile(
    '("/project/linuxlab/cadence/CDK/ncsu/models/spectre/nom/ami06N.m" "")
    '("/project/linuxlab/cadence/CDK/ncsu/models/spectre/nom/ami06P.m" "")
)
save( 'i "/N20/D" "/I37/gnd!" )
run()
selectResult( 'dc )
plot(getData("/N20/D") getData("/I37/gnd!") getData("/N15/D") getData("/I8/Squared") getData("/P15/D") )
modelFile(
    '("/project/linuxlab/cadence/CDK/ncsu/models/spectre/nom/ami06N.m" "")
    '("/project/linuxlab/cadence/CDK/ncsu/models/spectre/nom/ami06P.m" "")
)
run()
selectResult( 'dc )
plot(getData("/N20/D") )
modelFile(
    '("/project/linuxlab/cadence/CDK/ncsu/models/spectre/nom/ami06N.m" "")
    '("/project/linuxlab/cadence/CDK/ncsu/models/spectre/nom/ami06P.m" "")
)
save( 'i "/N19/D" )
run()
selectResult( 'dc )
plot(getData("/N20/D") getData("/N19/D") )
modelFile(
    '("/project/linuxlab/cadence/CDK/ncsu/models/spectre/nom/ami06N.m" "")
    '("/project/linuxlab/cadence/CDK/ncsu/models/spectre/nom/ami06P.m" "")
)
run()
selectResult( 'dc )
plot(getData("/I37/gnd!") getData("/N19/D") getData("/N20/D") )
modelFile(
    '("/project/linuxlab/cadence/CDK/ncsu/models/spectre/nom/ami06N.m" "")
    '("/project/linuxlab/cadence/CDK/ncsu/models/spectre/nom/ami06P.m" "")
)
save( 'i /N20/D /I37/gnd! /N19/D )
run()
selectResult( 'dc )
plot(getData("/P15/D") getData("/N15/D") getData("/I8/Squared") )
modelFile(
    '("/project/linuxlab/cadence/CDK/ncsu/models/spectre/nom/ami06N.m" "")
    '("/project/linuxlab/cadence/CDK/ncsu/models/spectre/nom/ami06P.m" "")
)
run()
selectResult( 'dc )
plot(getData("/P15/D") getData("/N15/D") getData("/I8/Squared") )
modelFile(
    '("/project/linuxlab/cadence/CDK/ncsu/models/spectre/nom/ami06N.m" "")
    '("/project/linuxlab/cadence/CDK/ncsu/models/spectre/nom/ami06P.m" "")
)
run()
selectResult( 'dc )
plot(getData("/N15/D") )
