// Design: cse562/mirror4
simulator lang=spectre
global 0 vdd!
parameters tW=15u tL=.5u
include "/project/linuxlab/cadence/CDK/ncsu/models/spectre/nom/ami06N.m"
include "/project/linuxlab/cadence/CDK/ncsu/models/spectre/nom/ami06P.m"

// cse562/mirror4/schematic
V1 (net6 0) vsource type=dc
V0 (vdd! 0) vsource type=dc dc=3
N5 (vdd! net6 0 0) ami06N w=tW l=tL m=1 region=sat
simulatorOptions options temp=27
dcOp dc
dc dc dev=V1 param=dc start=0 stop=.1
save N5:d
