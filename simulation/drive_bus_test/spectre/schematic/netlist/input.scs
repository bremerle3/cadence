// Generated for: spectre
// Generated on: May 11 19:43:00 2016
// Design library name: cse463_project
// Design cell name: drive_bus_test
// Design view name: schematic
simulator lang=spectre
global 0 vdd!
include "/project/linuxlab/cadence/CDK/ncsu/models/spectre/nom/ami06N.m"
include "/project/linuxlab/cadence/CDK/ncsu/models/spectre/nom/ami06P.m"

// Library name: cse463_project
// Cell name: bus_top
// View name: extracted
subckt bus_top AR_S0 AR_S0B AR_S1 AR_S1B DR_S0 DR_S0B DR_S1 DR_S1B F1 F2 \
        IR_N0 IR_N0B IR_N1 IR_N1B IR_S0 IR_S0B IR_S1 IR_S1B Input_S0 \
        Input_S0B Input_S1 Input_S1B Memory\<0\> Memory\<1\> Memory\<2\> \
        Memory\<3\> Memory\<4\> Memory\<5\> Memory\<6\> Memory\<7\> \
        OUTP_S0 OUTP_S0B OUTP_S1 OUTP_S1B PC_N0 PC_N0B PC_N1 PC_N1B PC_S0 \
        PC_S0B PC_S1 PC_S1B
    \+1754 (Memory\<0\> PC_N0 608 vdd!) ami06P w=1.8e-06 l=6e-07 \
        as=1.62e-12 ad=2.7e-12 ps=1.8e-06 pd=4.8e-06 m=1 region=sat
    \+1753 (Memory\<1\> PC_N0 609 vdd!) ami06P w=1.8e-06 l=6e-07 \
        as=1.62e-12 ad=2.7e-12 ps=1.8e-06 pd=4.8e-06 m=1 region=sat
    \+1752 (Memory\<2\> PC_N0 610 vdd!) ami06P w=1.8e-06 l=6e-07 \
        as=1.62e-12 ad=2.7e-12 ps=1.8e-06 pd=4.8e-06 m=1 region=sat
    \+1751 (Memory\<3\> PC_N0 611 vdd!) ami06P w=1.8e-06 l=6e-07 \
        as=1.62e-12 ad=2.7e-12 ps=1.8e-06 pd=4.8e-06 m=1 region=sat
    \+1750 (Memory\<4\> PC_N0 612 vdd!) ami06P w=1.8e-06 l=6e-07 \
        as=1.62e-12 ad=2.7e-12 ps=1.8e-06 pd=4.8e-06 m=1 region=sat
    \+1749 (608 PC_N1B 599 vdd!) ami06P w=1.8e-06 l=6e-07 as=2.7e-12 \
        ad=1.62e-12 ps=4.8e-06 pd=1.8e-06 m=1 region=sat
    \+1748 (609 PC_N1B 601 vdd!) ami06P w=1.8e-06 l=6e-07 as=2.7e-12 \
        ad=1.62e-12 ps=4.8e-06 pd=1.8e-06 m=1 region=sat
    \+1747 (610 PC_N1B 603 vdd!) ami06P w=1.8e-06 l=6e-07 as=2.7e-12 \
        ad=1.62e-12 ps=4.8e-06 pd=1.8e-06 m=1 region=sat
    \+1746 (611 PC_N1B 605 vdd!) ami06P w=1.8e-06 l=6e-07 as=2.7e-12 \
        ad=1.62e-12 ps=4.8e-06 pd=1.8e-06 m=1 region=sat
    \+1745 (612 PC_N1B 607 vdd!) ami06P w=1.8e-06 l=6e-07 as=2.7e-12 \
        ad=1.62e-12 ps=4.8e-06 pd=1.8e-06 m=1 region=sat
    \+1726 (Memory\<0\> IR_N0 586 vdd!) ami06P w=1.8e-06 l=6e-07 \
        as=1.62e-12 ad=2.7e-12 ps=1.8e-06 pd=4.8e-06 m=1 region=sat
    \+1725 (Memory\<1\> IR_N0 587 vdd!) ami06P w=1.8e-06 l=6e-07 \
        as=1.62e-12 ad=2.7e-12 ps=1.8e-06 pd=4.8e-06 m=1 region=sat
    \+1724 (Memory\<2\> IR_N0 588 vdd!) ami06P w=1.8e-06 l=6e-07 \
        as=1.62e-12 ad=2.7e-12 ps=1.8e-06 pd=4.8e-06 m=1 region=sat
    \+1723 (Memory\<3\> IR_N0 589 vdd!) ami06P w=1.8e-06 l=6e-07 \
        as=1.62e-12 ad=2.7e-12 ps=1.8e-06 pd=4.8e-06 m=1 region=sat
    \+1722 (Memory\<4\> IR_N0 590 vdd!) ami06P w=1.8e-06 l=6e-07 \
        as=1.62e-12 ad=2.7e-12 ps=1.8e-06 pd=4.8e-06 m=1 region=sat
    \+1721 (Memory\<5\> IR_N0 591 vdd!) ami06P w=1.8e-06 l=6e-07 \
        as=1.62e-12 ad=2.7e-12 ps=1.8e-06 pd=4.8e-06 m=1 region=sat
    \+1720 (Memory\<6\> IR_N0 592 vdd!) ami06P w=1.8e-06 l=6e-07 \
        as=1.62e-12 ad=2.7e-12 ps=1.8e-06 pd=4.8e-06 m=1 region=sat
    \+1719 (Memory\<7\> IR_N0 593 vdd!) ami06P w=1.8e-06 l=6e-07 \
        as=1.62e-12 ad=2.7e-12 ps=1.8e-06 pd=4.8e-06 m=1 region=sat
    \+1718 (592 IR_N1 583 vdd!) ami06P w=1.8e-06 l=6e-07 as=2.7e-12 \
        ad=1.62e-12 ps=4.8e-06 pd=1.8e-06 m=1 region=sat
    \+1717 (593 IR_N1 585 vdd!) ami06P w=1.8e-06 l=6e-07 as=2.7e-12 \
        ad=1.62e-12 ps=4.8e-06 pd=1.8e-06 m=1 region=sat
    \+1716 (586 IR_N1 571 vdd!) ami06P w=1.8e-06 l=6e-07 as=2.7e-12 \
        ad=1.62e-12 ps=4.8e-06 pd=1.8e-06 m=1 region=sat
    \+1715 (587 IR_N1 573 vdd!) ami06P w=1.8e-06 l=6e-07 as=2.7e-12 \
        ad=1.62e-12 ps=4.8e-06 pd=1.8e-06 m=1 region=sat
    \+1714 (588 IR_N1 575 vdd!) ami06P w=1.8e-06 l=6e-07 as=2.7e-12 \
        ad=1.62e-12 ps=4.8e-06 pd=1.8e-06 m=1 region=sat
    \+1713 (589 IR_N1 577 vdd!) ami06P w=1.8e-06 l=6e-07 as=2.7e-12 \
        ad=1.62e-12 ps=4.8e-06 pd=1.8e-06 m=1 region=sat
    \+1712 (590 IR_N1 579 vdd!) ami06P w=1.8e-06 l=6e-07 as=2.7e-12 \
        ad=1.62e-12 ps=4.8e-06 pd=1.8e-06 m=1 region=sat
    \+1711 (591 IR_N1 581 vdd!) ami06P w=1.8e-06 l=6e-07 as=2.7e-12 \
        ad=1.62e-12 ps=4.8e-06 pd=1.8e-06 m=1 region=sat
    \+1575 (Memory\<0\> 638 365 vdd!) ami06P w=1.8e-06 l=6e-07 as=1.62e-12 \
        ad=2.7e-12 ps=1.8e-06 pd=4.8e-06 m=1 region=sat
    \+1574 (Memory\<1\> 638 366 vdd!) ami06P w=1.8e-06 l=6e-07 as=1.62e-12 \
        ad=2.7e-12 ps=1.8e-06 pd=4.8e-06 m=1 region=sat
    \+1573 (Memory\<2\> 638 367 vdd!) ami06P w=1.8e-06 l=6e-07 as=1.62e-12 \
        ad=2.7e-12 ps=1.8e-06 pd=4.8e-06 m=1 region=sat
    \+1572 (Memory\<3\> 638 368 vdd!) ami06P w=1.8e-06 l=6e-07 as=1.62e-12 \
        ad=2.7e-12 ps=1.8e-06 pd=4.8e-06 m=1 region=sat
    \+1571 (Memory\<4\> 638 369 vdd!) ami06P w=1.8e-06 l=6e-07 as=1.62e-12 \
        ad=2.7e-12 ps=1.8e-06 pd=4.8e-06 m=1 region=sat
    \+1570 (Memory\<5\> 638 370 vdd!) ami06P w=1.8e-06 l=6e-07 as=1.62e-12 \
        ad=2.7e-12 ps=1.8e-06 pd=4.8e-06 m=1 region=sat
    \+1569 (Memory\<6\> 638 371 vdd!) ami06P w=1.8e-06 l=6e-07 as=1.62e-12 \
        ad=2.7e-12 ps=1.8e-06 pd=4.8e-06 m=1 region=sat
    \+1568 (Memory\<7\> 638 372 vdd!) ami06P w=1.8e-06 l=6e-07 as=1.62e-12 \
        ad=2.7e-12 ps=1.8e-06 pd=4.8e-06 m=1 region=sat
    \+1567 (370 635 360 vdd!) ami06P w=1.8e-06 l=6e-07 as=2.7e-12 \
        ad=1.62e-12 ps=4.8e-06 pd=1.8e-06 m=1 region=sat
    \+1566 (371 635 362 vdd!) ami06P w=1.8e-06 l=6e-07 as=2.7e-12 \
        ad=1.62e-12 ps=4.8e-06 pd=1.8e-06 m=1 region=sat
    \+1565 (372 635 364 vdd!) ami06P w=1.8e-06 l=6e-07 as=2.7e-12 \
        ad=1.62e-12 ps=4.8e-06 pd=1.8e-06 m=1 region=sat
    \+1564 (365 635 350 vdd!) ami06P w=1.8e-06 l=6e-07 as=2.7e-12 \
        ad=1.62e-12 ps=4.8e-06 pd=1.8e-06 m=1 region=sat
    \+1563 (366 635 352 vdd!) ami06P w=1.8e-06 l=6e-07 as=2.7e-12 \
        ad=1.62e-12 ps=4.8e-06 pd=1.8e-06 m=1 region=sat
    \+1562 (367 635 354 vdd!) ami06P w=1.8e-06 l=6e-07 as=2.7e-12 \
        ad=1.62e-12 ps=4.8e-06 pd=1.8e-06 m=1 region=sat
    \+1561 (368 635 356 vdd!) ami06P w=1.8e-06 l=6e-07 as=2.7e-12 \
        ad=1.62e-12 ps=4.8e-06 pd=1.8e-06 m=1 region=sat
    \+1560 (369 635 358 vdd!) ami06P w=1.8e-06 l=6e-07 as=2.7e-12 \
        ad=1.62e-12 ps=4.8e-06 pd=1.8e-06 m=1 region=sat
    \+1303 (Memory\<0\> PC_N0B 608 44) ami06N w=1.8e-06 l=6e-07 \
        as=1.62e-12 ad=2.7e-12 ps=1.8e-06 pd=4.8e-06 m=1 region=sat
    \+1302 (Memory\<1\> PC_N0B 609 44) ami06N w=1.8e-06 l=6e-07 \
        as=1.62e-12 ad=2.7e-12 ps=1.8e-06 pd=4.8e-06 m=1 region=sat
    \+1301 (Memory\<2\> PC_N0B 610 44) ami06N w=1.8e-06 l=6e-07 \
        as=1.62e-12 ad=2.7e-12 ps=1.8e-06 pd=4.8e-06 m=1 region=sat
    \+1300 (Memory\<3\> PC_N0B 611 44) ami06N w=1.8e-06 l=6e-07 \
        as=1.62e-12 ad=2.7e-12 ps=1.8e-06 pd=4.8e-06 m=1 region=sat
    \+1299 (Memory\<4\> PC_N0B 612 44) ami06N w=1.8e-06 l=6e-07 \
        as=1.62e-12 ad=2.7e-12 ps=1.8e-06 pd=4.8e-06 m=1 region=sat
    \+1298 (610 PC_N1 603 44) ami06N w=1.8e-06 l=6e-07 as=2.7e-12 \
        ad=1.62e-12 ps=4.8e-06 pd=1.8e-06 m=1 region=sat
    \+1297 (611 PC_N1 605 44) ami06N w=1.8e-06 l=6e-07 as=2.7e-12 \
        ad=1.62e-12 ps=4.8e-06 pd=1.8e-06 m=1 region=sat
    \+1296 (612 PC_N1 607 44) ami06N w=1.8e-06 l=6e-07 as=2.7e-12 \
        ad=1.62e-12 ps=4.8e-06 pd=1.8e-06 m=1 region=sat
    \+1295 (608 PC_N1 599 44) ami06N w=1.8e-06 l=6e-07 as=2.7e-12 \
        ad=1.62e-12 ps=4.8e-06 pd=1.8e-06 m=1 region=sat
    \+1294 (609 PC_N1 601 44) ami06N w=1.8e-06 l=6e-07 as=2.7e-12 \
        ad=1.62e-12 ps=4.8e-06 pd=1.8e-06 m=1 region=sat
    \+1275 (Memory\<5\> IR_N0B 591 44) ami06N w=1.8e-06 l=6e-07 \
        as=1.62e-12 ad=2.7e-12 ps=1.8e-06 pd=4.8e-06 m=1 region=sat
    \+1274 (Memory\<6\> IR_N0B 592 44) ami06N w=1.8e-06 l=6e-07 \
        as=1.62e-12 ad=2.7e-12 ps=1.8e-06 pd=4.8e-06 m=1 region=sat
    \+1273 (Memory\<7\> IR_N0B 593 44) ami06N w=1.8e-06 l=6e-07 \
        as=1.62e-12 ad=2.7e-12 ps=1.8e-06 pd=4.8e-06 m=1 region=sat
    \+1272 (Memory\<0\> IR_N0B 586 44) ami06N w=1.8e-06 l=6e-07 \
        as=1.62e-12 ad=2.7e-12 ps=1.8e-06 pd=4.8e-06 m=1 region=sat
    \+1271 (Memory\<1\> IR_N0B 587 44) ami06N w=1.8e-06 l=6e-07 \
        as=1.62e-12 ad=2.7e-12 ps=1.8e-06 pd=4.8e-06 m=1 region=sat
    \+1270 (Memory\<2\> IR_N0B 588 44) ami06N w=1.8e-06 l=6e-07 \
        as=1.62e-12 ad=2.7e-12 ps=1.8e-06 pd=4.8e-06 m=1 region=sat
    \+1269 (Memory\<3\> IR_N0B 589 44) ami06N w=1.8e-06 l=6e-07 \
        as=1.62e-12 ad=2.7e-12 ps=1.8e-06 pd=4.8e-06 m=1 region=sat
    \+1268 (Memory\<4\> IR_N0B 590 44) ami06N w=1.8e-06 l=6e-07 \
        as=1.62e-12 ad=2.7e-12 ps=1.8e-06 pd=4.8e-06 m=1 region=sat
    \+1257 (586 IR_N1B 571 44) ami06N w=1.8e-06 l=6e-07 as=2.7e-12 \
        ad=1.62e-12 ps=4.8e-06 pd=1.8e-06 m=1 region=sat
    \+1256 (587 IR_N1B 573 44) ami06N w=1.8e-06 l=6e-07 as=2.7e-12 \
        ad=1.62e-12 ps=4.8e-06 pd=1.8e-06 m=1 region=sat
    \+1255 (588 IR_N1B 575 44) ami06N w=1.8e-06 l=6e-07 as=2.7e-12 \
        ad=1.62e-12 ps=4.8e-06 pd=1.8e-06 m=1 region=sat
    \+1254 (589 IR_N1B 577 44) ami06N w=1.8e-06 l=6e-07 as=2.7e-12 \
        ad=1.62e-12 ps=4.8e-06 pd=1.8e-06 m=1 region=sat
    \+1253 (590 IR_N1B 579 44) ami06N w=1.8e-06 l=6e-07 as=2.7e-12 \
        ad=1.62e-12 ps=4.8e-06 pd=1.8e-06 m=1 region=sat
    \+1252 (591 IR_N1B 581 44) ami06N w=1.8e-06 l=6e-07 as=2.7e-12 \
        ad=1.62e-12 ps=4.8e-06 pd=1.8e-06 m=1 region=sat
    \+1251 (592 IR_N1B 583 44) ami06N w=1.8e-06 l=6e-07 as=2.7e-12 \
        ad=1.62e-12 ps=4.8e-06 pd=1.8e-06 m=1 region=sat
    \+1250 (593 IR_N1B 585 44) ami06N w=1.8e-06 l=6e-07 as=2.7e-12 \
        ad=1.62e-12 ps=4.8e-06 pd=1.8e-06 m=1 region=sat
    \+839 (Memory\<4\> 637 369 44) ami06N w=1.8e-06 l=6e-07 as=1.62e-12 \
        ad=2.7e-12 ps=1.8e-06 pd=4.8e-06 m=1 region=sat
    \+838 (Memory\<5\> 637 370 44) ami06N w=1.8e-06 l=6e-07 as=1.62e-12 \
        ad=2.7e-12 ps=1.8e-06 pd=4.8e-06 m=1 region=sat
    \+837 (Memory\<6\> 637 371 44) ami06N w=1.8e-06 l=6e-07 as=1.62e-12 \
        ad=2.7e-12 ps=1.8e-06 pd=4.8e-06 m=1 region=sat
    \+836 (Memory\<7\> 637 372 44) ami06N w=1.8e-06 l=6e-07 as=1.62e-12 \
        ad=2.7e-12 ps=1.8e-06 pd=4.8e-06 m=1 region=sat
    \+835 (Memory\<0\> 637 365 44) ami06N w=1.8e-06 l=6e-07 as=1.62e-12 \
        ad=2.7e-12 ps=1.8e-06 pd=4.8e-06 m=1 region=sat
    \+834 (Memory\<1\> 637 366 44) ami06N w=1.8e-06 l=6e-07 as=1.62e-12 \
        ad=2.7e-12 ps=1.8e-06 pd=4.8e-06 m=1 region=sat
    \+833 (Memory\<2\> 637 367 44) ami06N w=1.8e-06 l=6e-07 as=1.62e-12 \
        ad=2.7e-12 ps=1.8e-06 pd=4.8e-06 m=1 region=sat
    \+832 (Memory\<3\> 637 368 44) ami06N w=1.8e-06 l=6e-07 as=1.62e-12 \
        ad=2.7e-12 ps=1.8e-06 pd=4.8e-06 m=1 region=sat
    \+831 (365 636 350 44) ami06N w=1.8e-06 l=6e-07 as=2.7e-12 ad=1.62e-12 \
        ps=4.8e-06 pd=1.8e-06 m=1 region=sat
    \+830 (366 636 352 44) ami06N w=1.8e-06 l=6e-07 as=2.7e-12 ad=1.62e-12 \
        ps=4.8e-06 pd=1.8e-06 m=1 region=sat
    \+829 (367 636 354 44) ami06N w=1.8e-06 l=6e-07 as=2.7e-12 ad=1.62e-12 \
        ps=4.8e-06 pd=1.8e-06 m=1 region=sat
    \+828 (368 636 356 44) ami06N w=1.8e-06 l=6e-07 as=2.7e-12 ad=1.62e-12 \
        ps=4.8e-06 pd=1.8e-06 m=1 region=sat
    \+827 (369 636 358 44) ami06N w=1.8e-06 l=6e-07 as=2.7e-12 ad=1.62e-12 \
        ps=4.8e-06 pd=1.8e-06 m=1 region=sat
    \+826 (370 636 360 44) ami06N w=1.8e-06 l=6e-07 as=2.7e-12 ad=1.62e-12 \
        ps=4.8e-06 pd=1.8e-06 m=1 region=sat
    \+825 (371 636 362 44) ami06N w=1.8e-06 l=6e-07 as=2.7e-12 ad=1.62e-12 \
        ps=4.8e-06 pd=1.8e-06 m=1 region=sat
    \+824 (372 636 364 44) ami06N w=1.8e-06 l=6e-07 as=2.7e-12 ad=1.62e-12 \
        ps=4.8e-06 pd=1.8e-06 m=1 region=sat
    \+1293 (598 381 44 44) ami06N w=9e-07 l=6e-07 as=1.71e-12 ad=1.71e-12 \
        ps=4.5e-06 pd=4.5e-06 m=1 region=sat
    \+1292 (599 598 44 44) ami06N w=9e-07 l=6e-07 as=1.71e-12 ad=1.71e-12 \
        ps=4.5e-06 pd=4.5e-06 m=1 region=sat
    \+1291 (600 383 44 44) ami06N w=9e-07 l=6e-07 as=1.71e-12 ad=1.71e-12 \
        ps=4.5e-06 pd=4.5e-06 m=1 region=sat
    \+1290 (601 600 44 44) ami06N w=9e-07 l=6e-07 as=1.71e-12 ad=1.71e-12 \
        ps=4.5e-06 pd=4.5e-06 m=1 region=sat
    \+1289 (602 385 44 44) ami06N w=9e-07 l=6e-07 as=1.71e-12 ad=1.71e-12 \
        ps=4.5e-06 pd=4.5e-06 m=1 region=sat
    \+1288 (603 602 44 44) ami06N w=9e-07 l=6e-07 as=1.71e-12 ad=1.71e-12 \
        ps=4.5e-06 pd=4.5e-06 m=1 region=sat
    \+1287 (604 387 44 44) ami06N w=9e-07 l=6e-07 as=1.71e-12 ad=1.71e-12 \
        ps=4.5e-06 pd=4.5e-06 m=1 region=sat
    \+1286 (605 604 44 44) ami06N w=9e-07 l=6e-07 as=1.71e-12 ad=1.71e-12 \
        ps=4.5e-06 pd=4.5e-06 m=1 region=sat
    \+1285 (606 389 44 44) ami06N w=9e-07 l=6e-07 as=1.71e-12 ad=1.71e-12 \
        ps=4.5e-06 pd=4.5e-06 m=1 region=sat
    \+1284 (607 606 44 44) ami06N w=9e-07 l=6e-07 as=1.71e-12 ad=1.71e-12 \
        ps=4.5e-06 pd=4.5e-06 m=1 region=sat
    \+1283 (594 560 44 44) ami06N w=9e-07 l=6e-07 as=9.9e-13 ad=1.71e-12 \
        ps=2.1e-06 pd=4.5e-06 m=1 region=sat
    \+1282 (595 562 44 44) ami06N w=9e-07 l=6e-07 as=9.9e-13 ad=1.71e-12 \
        ps=2.1e-06 pd=4.5e-06 m=1 region=sat
    \+1281 (596 564 44 44) ami06N w=9e-07 l=6e-07 as=9.9e-13 ad=1.71e-12 \
        ps=2.1e-06 pd=4.5e-06 m=1 region=sat
    \+1280 (597 566 44 44) ami06N w=9e-07 l=6e-07 as=9.9e-13 ad=1.71e-12 \
        ps=2.1e-06 pd=4.5e-06 m=1 region=sat
    \+1279 (44 561 594 44) ami06N w=9e-07 l=6e-07 as=1.71e-12 ad=9.9e-13 \
        ps=4.5e-06 pd=2.1e-06 m=1 region=sat
    \+1278 (44 563 595 44) ami06N w=9e-07 l=6e-07 as=1.71e-12 ad=9.9e-13 \
        ps=4.5e-06 pd=2.1e-06 m=1 region=sat
    \+1277 (44 565 596 44) ami06N w=9e-07 l=6e-07 as=1.71e-12 ad=9.9e-13 \
        ps=4.5e-06 pd=2.1e-06 m=1 region=sat
    \+1276 (44 567 597 44) ami06N w=9e-07 l=6e-07 as=1.71e-12 ad=9.9e-13 \
        ps=4.5e-06 pd=2.1e-06 m=1 region=sat
    \+1239 (573 572 44 44) ami06N w=9e-07 l=6e-07 as=1.71e-12 ad=1.71e-12 \
        ps=4.5e-06 pd=4.5e-06 m=1 region=sat
    \+1238 (574 375 44 44) ami06N w=9e-07 l=6e-07 as=1.71e-12 ad=1.71e-12 \
        ps=4.5e-06 pd=4.5e-06 m=1 region=sat
    \+1237 (575 574 44 44) ami06N w=9e-07 l=6e-07 as=1.71e-12 ad=1.71e-12 \
        ps=4.5e-06 pd=4.5e-06 m=1 region=sat
    \+1236 (576 376 44 44) ami06N w=9e-07 l=6e-07 as=1.71e-12 ad=1.71e-12 \
        ps=4.5e-06 pd=4.5e-06 m=1 region=sat
    \+1235 (577 576 44 44) ami06N w=9e-07 l=6e-07 as=1.71e-12 ad=1.71e-12 \
        ps=4.5e-06 pd=4.5e-06 m=1 region=sat
    \+1234 (578 377 44 44) ami06N w=9e-07 l=6e-07 as=1.71e-12 ad=1.71e-12 \
        ps=4.5e-06 pd=4.5e-06 m=1 region=sat
    \+1233 (579 578 44 44) ami06N w=9e-07 l=6e-07 as=1.71e-12 ad=1.71e-12 \
        ps=4.5e-06 pd=4.5e-06 m=1 region=sat
    \+1232 (580 378 44 44) ami06N w=9e-07 l=6e-07 as=1.71e-12 ad=1.71e-12 \
        ps=4.5e-06 pd=4.5e-06 m=1 region=sat
    \+1231 (581 580 44 44) ami06N w=9e-07 l=6e-07 as=1.71e-12 ad=1.71e-12 \
        ps=4.5e-06 pd=4.5e-06 m=1 region=sat
    \+1230 (582 379 44 44) ami06N w=9e-07 l=6e-07 as=1.71e-12 ad=1.71e-12 \
        ps=4.5e-06 pd=4.5e-06 m=1 region=sat
    \+1229 (583 582 44 44) ami06N w=9e-07 l=6e-07 as=1.71e-12 ad=1.71e-12 \
        ps=4.5e-06 pd=4.5e-06 m=1 region=sat
    \+1228 (584 380 44 44) ami06N w=9e-07 l=6e-07 as=1.71e-12 ad=1.71e-12 \
        ps=4.5e-06 pd=4.5e-06 m=1 region=sat
    \+1227 (585 584 44 44) ami06N w=9e-07 l=6e-07 as=1.71e-12 ad=1.71e-12 \
        ps=4.5e-06 pd=4.5e-06 m=1 region=sat
    \+1226 (570 373 44 44) ami06N w=9e-07 l=6e-07 as=1.71e-12 ad=1.71e-12 \
        ps=4.5e-06 pd=4.5e-06 m=1 region=sat
    \+1225 (571 570 44 44) ami06N w=9e-07 l=6e-07 as=1.71e-12 ad=1.71e-12 \
        ps=4.5e-06 pd=4.5e-06 m=1 region=sat
    \+1224 (572 374 44 44) ami06N w=9e-07 l=6e-07 as=1.71e-12 ad=1.71e-12 \
        ps=4.5e-06 pd=4.5e-06 m=1 region=sat
    \+1223 (560 vdd! 44 44) ami06N w=9e-07 l=6e-07 as=1.71e-12 ad=1.71e-12 \
        ps=4.5e-06 pd=4.5e-06 m=1 region=sat
    \+1222 (561 381 44 44) ami06N w=9e-07 l=6e-07 as=1.71e-12 ad=1.71e-12 \
        ps=4.5e-06 pd=4.5e-06 m=1 region=sat
    \+1221 (562 594 44 44) ami06N w=9e-07 l=6e-07 as=1.71e-12 ad=1.71e-12 \
        ps=4.5e-06 pd=4.5e-06 m=1 region=sat
    \+1220 (563 383 44 44) ami06N w=9e-07 l=6e-07 as=1.71e-12 ad=1.71e-12 \
        ps=4.5e-06 pd=4.5e-06 m=1 region=sat
    \+1219 (564 595 44 44) ami06N w=9e-07 l=6e-07 as=1.71e-12 ad=1.71e-12 \
        ps=4.5e-06 pd=4.5e-06 m=1 region=sat
    \+1218 (565 385 44 44) ami06N w=9e-07 l=6e-07 as=1.71e-12 ad=1.71e-12 \
        ps=4.5e-06 pd=4.5e-06 m=1 region=sat
    \+1217 (566 596 44 44) ami06N w=9e-07 l=6e-07 as=1.71e-12 ad=1.71e-12 \
        ps=4.5e-06 pd=4.5e-06 m=1 region=sat
    \+1216 (567 387 44 44) ami06N w=9e-07 l=6e-07 as=1.71e-12 ad=1.71e-12 \
        ps=4.5e-06 pd=4.5e-06 m=1 region=sat
    \+1215 (568 597 44 44) ami06N w=9e-07 l=6e-07 as=1.71e-12 ad=1.71e-12 \
        ps=4.5e-06 pd=4.5e-06 m=1 region=sat
    \+1214 (569 389 44 44) ami06N w=9e-07 l=6e-07 as=1.71e-12 ad=1.71e-12 \
        ps=4.5e-06 pd=4.5e-06 m=1 region=sat
    \+1213 (394 524 44 44) ami06N w=9e-07 l=6e-07 as=1.71e-12 ad=1.71e-12 \
        ps=4.5e-06 pd=4.5e-06 m=1 region=sat
    \+1212 (395 525 44 44) ami06N w=9e-07 l=6e-07 as=1.71e-12 ad=1.71e-12 \
        ps=4.5e-06 pd=4.5e-06 m=1 region=sat
    \+1211 (396 526 44 44) ami06N w=9e-07 l=6e-07 as=1.71e-12 ad=1.71e-12 \
        ps=4.5e-06 pd=4.5e-06 m=1 region=sat
    \+1210 (397 527 44 44) ami06N w=9e-07 l=6e-07 as=1.71e-12 ad=1.71e-12 \
        ps=4.5e-06 pd=4.5e-06 m=1 region=sat
    \+1209 (398 528 44 44) ami06N w=9e-07 l=6e-07 as=1.71e-12 ad=1.71e-12 \
        ps=4.5e-06 pd=4.5e-06 m=1 region=sat
    \+1208 (399 529 44 44) ami06N w=9e-07 l=6e-07 as=1.71e-12 ad=1.71e-12 \
        ps=4.5e-06 pd=4.5e-06 m=1 region=sat
    \+1207 (400 530 44 44) ami06N w=9e-07 l=6e-07 as=1.71e-12 ad=1.71e-12 \
        ps=4.5e-06 pd=4.5e-06 m=1 region=sat
    \+1206 (373 508 44 44) ami06N w=9e-07 l=6e-07 as=1.71e-12 ad=1.71e-12 \
        ps=4.5e-06 pd=4.5e-06 m=1 region=sat
    \+1205 (401 531 44 44) ami06N w=9e-07 l=6e-07 as=1.71e-12 ad=1.71e-12 \
        ps=4.5e-06 pd=4.5e-06 m=1 region=sat
    \+1204 (374 509 44 44) ami06N w=9e-07 l=6e-07 as=1.71e-12 ad=1.71e-12 \
        ps=4.5e-06 pd=4.5e-06 m=1 region=sat
    \+1203 (402 532 44 44) ami06N w=9e-07 l=6e-07 as=1.71e-12 ad=1.71e-12 \
        ps=4.5e-06 pd=4.5e-06 m=1 region=sat
    \+1202 (375 510 44 44) ami06N w=9e-07 l=6e-07 as=1.71e-12 ad=1.71e-12 \
        ps=4.5e-06 pd=4.5e-06 m=1 region=sat
    \+1201 (403 533 44 44) ami06N w=9e-07 l=6e-07 as=1.71e-12 ad=1.71e-12 \
        ps=4.5e-06 pd=4.5e-06 m=1 region=sat
    \+1200 (376 511 44 44) ami06N w=9e-07 l=6e-07 as=1.71e-12 ad=1.71e-12 \
        ps=4.5e-06 pd=4.5e-06 m=1 region=sat
    \+1199 (377 512 44 44) ami06N w=9e-07 l=6e-07 as=1.71e-12 ad=1.71e-12 \
        ps=4.5e-06 pd=4.5e-06 m=1 region=sat
    \+1198 (378 513 44 44) ami06N w=9e-07 l=6e-07 as=1.71e-12 ad=1.71e-12 \
        ps=4.5e-06 pd=4.5e-06 m=1 region=sat
    \+1197 (379 514 44 44) ami06N w=9e-07 l=6e-07 as=1.71e-12 ad=1.71e-12 \
        ps=4.5e-06 pd=4.5e-06 m=1 region=sat
    \+1196 (380 515 44 44) ami06N w=9e-07 l=6e-07 as=1.71e-12 ad=1.71e-12 \
        ps=4.5e-06 pd=4.5e-06 m=1 region=sat
    \+1195 (381 516 44 44) ami06N w=9e-07 l=6e-07 as=1.71e-12 ad=1.71e-12 \
        ps=4.5e-06 pd=4.5e-06 m=1 region=sat
    \+1194 (383 517 44 44) ami06N w=9e-07 l=6e-07 as=1.71e-12 ad=1.71e-12 \
        ps=4.5e-06 pd=4.5e-06 m=1 region=sat
    \+1193 (385 518 44 44) ami06N w=9e-07 l=6e-07 as=1.71e-12 ad=1.71e-12 \
        ps=4.5e-06 pd=4.5e-06 m=1 region=sat
    \+1192 (387 519 44 44) ami06N w=9e-07 l=6e-07 as=1.71e-12 ad=1.71e-12 \
        ps=4.5e-06 pd=4.5e-06 m=1 region=sat
    \+1191 (389 520 44 44) ami06N w=9e-07 l=6e-07 as=1.71e-12 ad=1.71e-12 \
        ps=4.5e-06 pd=4.5e-06 m=1 region=sat
    \+1190 (391 521 44 44) ami06N w=9e-07 l=6e-07 as=1.71e-12 ad=1.71e-12 \
        ps=4.5e-06 pd=4.5e-06 m=1 region=sat
    \+1189 (392 522 44 44) ami06N w=9e-07 l=6e-07 as=1.71e-12 ad=1.71e-12 \
        ps=4.5e-06 pd=4.5e-06 m=1 region=sat
    \+1188 (393 523 44 44) ami06N w=9e-07 l=6e-07 as=1.71e-12 ad=1.71e-12 \
        ps=4.5e-06 pd=4.5e-06 m=1 region=sat
    \+1187 (44 397 553 44) ami06N w=9e-07 l=6e-07 as=1.71e-12 ad=1.71e-12 \
        ps=4.5e-06 pd=4.5e-06 m=1 region=sat
    \+1186 (44 398 554 44) ami06N w=9e-07 l=6e-07 as=1.71e-12 ad=1.71e-12 \
        ps=4.5e-06 pd=4.5e-06 m=1 region=sat
    \+1185 (44 399 555 44) ami06N w=9e-07 l=6e-07 as=1.71e-12 ad=1.71e-12 \
        ps=4.5e-06 pd=4.5e-06 m=1 region=sat
    \+1184 (44 400 556 44) ami06N w=9e-07 l=6e-07 as=1.71e-12 ad=1.71e-12 \
        ps=4.5e-06 pd=4.5e-06 m=1 region=sat
    \+1183 (44 373 534 44) ami06N w=9e-07 l=6e-07 as=1.71e-12 ad=1.71e-12 \
        ps=4.5e-06 pd=4.5e-06 m=1 region=sat
    \+1182 (44 401 557 44) ami06N w=9e-07 l=6e-07 as=1.71e-12 ad=1.71e-12 \
        ps=4.5e-06 pd=4.5e-06 m=1 region=sat
    \+1181 (44 374 535 44) ami06N w=9e-07 l=6e-07 as=1.71e-12 ad=1.71e-12 \
        ps=4.5e-06 pd=4.5e-06 m=1 region=sat
    \+1180 (44 402 558 44) ami06N w=9e-07 l=6e-07 as=1.71e-12 ad=1.71e-12 \
        ps=4.5e-06 pd=4.5e-06 m=1 region=sat
    \+1179 (44 375 536 44) ami06N w=9e-07 l=6e-07 as=1.71e-12 ad=1.71e-12 \
        ps=4.5e-06 pd=4.5e-06 m=1 region=sat
    \+1178 (44 403 559 44) ami06N w=9e-07 l=6e-07 as=1.71e-12 ad=1.71e-12 \
        ps=4.5e-06 pd=4.5e-06 m=1 region=sat
    \+1177 (44 376 537 44) ami06N w=9e-07 l=6e-07 as=1.71e-12 ad=1.71e-12 \
        ps=4.5e-06 pd=4.5e-06 m=1 region=sat
    \+1176 (44 377 538 44) ami06N w=9e-07 l=6e-07 as=1.71e-12 ad=1.71e-12 \
        ps=4.5e-06 pd=4.5e-06 m=1 region=sat
    \+1175 (44 378 539 44) ami06N w=9e-07 l=6e-07 as=1.71e-12 ad=1.71e-12 \
        ps=4.5e-06 pd=4.5e-06 m=1 region=sat
    \+1174 (44 379 540 44) ami06N w=9e-07 l=6e-07 as=1.71e-12 ad=1.71e-12 \
        ps=4.5e-06 pd=4.5e-06 m=1 region=sat
    \+1173 (44 380 541 44) ami06N w=9e-07 l=6e-07 as=1.71e-12 ad=1.71e-12 \
        ps=4.5e-06 pd=4.5e-06 m=1 region=sat
    \+1172 (44 381 542 44) ami06N w=9e-07 l=6e-07 as=1.71e-12 ad=1.71e-12 \
        ps=4.5e-06 pd=4.5e-06 m=1 region=sat
    \+1171 (44 383 543 44) ami06N w=9e-07 l=6e-07 as=1.71e-12 ad=1.71e-12 \
        ps=4.5e-06 pd=4.5e-06 m=1 region=sat
    \+1170 (44 385 544 44) ami06N w=9e-07 l=6e-07 as=1.71e-12 ad=1.71e-12 \
        ps=4.5e-06 pd=4.5e-06 m=1 region=sat
    \+1169 (44 387 545 44) ami06N w=9e-07 l=6e-07 as=1.71e-12 ad=1.71e-12 \
        ps=4.5e-06 pd=4.5e-06 m=1 region=sat
    \+1168 (44 389 546 44) ami06N w=9e-07 l=6e-07 as=1.71e-12 ad=1.71e-12 \
        ps=4.5e-06 pd=4.5e-06 m=1 region=sat
    \+1167 (44 391 547 44) ami06N w=9e-07 l=6e-07 as=1.71e-12 ad=1.71e-12 \
        ps=4.5e-06 pd=4.5e-06 m=1 region=sat
    \+1166 (44 392 548 44) ami06N w=9e-07 l=6e-07 as=1.71e-12 ad=1.71e-12 \
        ps=4.5e-06 pd=4.5e-06 m=1 region=sat
    \+1165 (44 393 549 44) ami06N w=9e-07 l=6e-07 as=1.71e-12 ad=1.71e-12 \
        ps=4.5e-06 pd=4.5e-06 m=1 region=sat
    \+1164 (44 394 550 44) ami06N w=9e-07 l=6e-07 as=1.71e-12 ad=1.71e-12 \
        ps=4.5e-06 pd=4.5e-06 m=1 region=sat
    \+1163 (44 395 551 44) ami06N w=9e-07 l=6e-07 as=1.71e-12 ad=1.71e-12 \
        ps=4.5e-06 pd=4.5e-06 m=1 region=sat
    \+1162 (44 396 552 44) ami06N w=9e-07 l=6e-07 as=1.71e-12 ad=1.71e-12 \
        ps=4.5e-06 pd=4.5e-06 m=1 region=sat
    \+1161 (556 F1 530 44) ami06N w=9e-07 l=6e-07 as=1.71e-12 ad=1.71e-12 \
        ps=4.5e-06 pd=4.5e-06 m=1 region=sat
    \+1160 (534 F1 508 44) ami06N w=9e-07 l=6e-07 as=1.71e-12 ad=1.71e-12 \
        ps=4.5e-06 pd=4.5e-06 m=1 region=sat
    \+1159 (557 F1 531 44) ami06N w=9e-07 l=6e-07 as=1.71e-12 ad=1.71e-12 \
        ps=4.5e-06 pd=4.5e-06 m=1 region=sat
    \+1158 (535 F1 509 44) ami06N w=9e-07 l=6e-07 as=1.71e-12 ad=1.71e-12 \
        ps=4.5e-06 pd=4.5e-06 m=1 region=sat
    \+1157 (558 F1 532 44) ami06N w=9e-07 l=6e-07 as=1.71e-12 ad=1.71e-12 \
        ps=4.5e-06 pd=4.5e-06 m=1 region=sat
    \+1156 (536 F1 510 44) ami06N w=9e-07 l=6e-07 as=1.71e-12 ad=1.71e-12 \
        ps=4.5e-06 pd=4.5e-06 m=1 region=sat
    \+1155 (559 F1 533 44) ami06N w=9e-07 l=6e-07 as=1.71e-12 ad=1.71e-12 \
        ps=4.5e-06 pd=4.5e-06 m=1 region=sat
    \+1154 (537 F1 511 44) ami06N w=9e-07 l=6e-07 as=1.71e-12 ad=1.71e-12 \
        ps=4.5e-06 pd=4.5e-06 m=1 region=sat
    \+1153 (538 F1 512 44) ami06N w=9e-07 l=6e-07 as=1.71e-12 ad=1.71e-12 \
        ps=4.5e-06 pd=4.5e-06 m=1 region=sat
    \+1152 (539 F1 513 44) ami06N w=9e-07 l=6e-07 as=1.71e-12 ad=1.71e-12 \
        ps=4.5e-06 pd=4.5e-06 m=1 region=sat
    \+1151 (540 F1 514 44) ami06N w=9e-07 l=6e-07 as=1.71e-12 ad=1.71e-12 \
        ps=4.5e-06 pd=4.5e-06 m=1 region=sat
    \+1150 (541 F1 515 44) ami06N w=9e-07 l=6e-07 as=1.71e-12 ad=1.71e-12 \
        ps=4.5e-06 pd=4.5e-06 m=1 region=sat
    \+1149 (542 F1 516 44) ami06N w=9e-07 l=6e-07 as=1.71e-12 ad=1.71e-12 \
        ps=4.5e-06 pd=4.5e-06 m=1 region=sat
    \+1148 (543 F1 517 44) ami06N w=9e-07 l=6e-07 as=1.71e-12 ad=1.71e-12 \
        ps=4.5e-06 pd=4.5e-06 m=1 region=sat
    \+1147 (544 F1 518 44) ami06N w=9e-07 l=6e-07 as=1.71e-12 ad=1.71e-12 \
        ps=4.5e-06 pd=4.5e-06 m=1 region=sat
    \+1146 (545 F1 519 44) ami06N w=9e-07 l=6e-07 as=1.71e-12 ad=1.71e-12 \
        ps=4.5e-06 pd=4.5e-06 m=1 region=sat
    \+1145 (546 F1 520 44) ami06N w=9e-07 l=6e-07 as=1.71e-12 ad=1.71e-12 \
        ps=4.5e-06 pd=4.5e-06 m=1 region=sat
    \+1144 (547 F1 521 44) ami06N w=9e-07 l=6e-07 as=1.71e-12 ad=1.71e-12 \
        ps=4.5e-06 pd=4.5e-06 m=1 region=sat
    \+1143 (548 F1 522 44) ami06N w=9e-07 l=6e-07 as=1.71e-12 ad=1.71e-12 \
        ps=4.5e-06 pd=4.5e-06 m=1 region=sat
    \+1142 (549 F1 523 44) ami06N w=9e-07 l=6e-07 as=1.71e-12 ad=1.71e-12 \
        ps=4.5e-06 pd=4.5e-06 m=1 region=sat
    \+1141 (550 F1 524 44) ami06N w=9e-07 l=6e-07 as=1.71e-12 ad=1.71e-12 \
        ps=4.5e-06 pd=4.5e-06 m=1 region=sat
    \+1140 (551 F1 525 44) ami06N w=9e-07 l=6e-07 as=1.71e-12 ad=1.71e-12 \
        ps=4.5e-06 pd=4.5e-06 m=1 region=sat
    \+1139 (552 F1 526 44) ami06N w=9e-07 l=6e-07 as=1.71e-12 ad=1.71e-12 \
        ps=4.5e-06 pd=4.5e-06 m=1 region=sat
    \+1138 (553 F1 527 44) ami06N w=9e-07 l=6e-07 as=1.71e-12 ad=1.71e-12 \
        ps=4.5e-06 pd=4.5e-06 m=1 region=sat
    \+1137 (554 F1 528 44) ami06N w=9e-07 l=6e-07 as=1.71e-12 ad=1.71e-12 \
        ps=4.5e-06 pd=4.5e-06 m=1 region=sat
    \+1136 (555 F1 529 44) ami06N w=9e-07 l=6e-07 as=1.71e-12 ad=1.71e-12 \
        ps=4.5e-06 pd=4.5e-06 m=1 region=sat
    \+1135 (510 F2 484 44) ami06N w=9e-07 l=6e-07 as=1.71e-12 ad=1.71e-12 \
        ps=4.5e-06 pd=4.5e-06 m=1 region=sat
    \+1134 (533 F2 507 44) ami06N w=9e-07 l=6e-07 as=1.71e-12 ad=1.71e-12 \
        ps=4.5e-06 pd=4.5e-06 m=1 region=sat
    \+1133 (511 F2 485 44) ami06N w=9e-07 l=6e-07 as=1.71e-12 ad=1.71e-12 \
        ps=4.5e-06 pd=4.5e-06 m=1 region=sat
    \+1132 (512 F2 486 44) ami06N w=9e-07 l=6e-07 as=1.71e-12 ad=1.71e-12 \
        ps=4.5e-06 pd=4.5e-06 m=1 region=sat
    \+1131 (513 F2 487 44) ami06N w=9e-07 l=6e-07 as=1.71e-12 ad=1.71e-12 \
        ps=4.5e-06 pd=4.5e-06 m=1 region=sat
    \+1130 (514 F2 488 44) ami06N w=9e-07 l=6e-07 as=1.71e-12 ad=1.71e-12 \
        ps=4.5e-06 pd=4.5e-06 m=1 region=sat
    \+1129 (515 F2 489 44) ami06N w=9e-07 l=6e-07 as=1.71e-12 ad=1.71e-12 \
        ps=4.5e-06 pd=4.5e-06 m=1 region=sat
    \+1128 (516 F2 490 44) ami06N w=9e-07 l=6e-07 as=1.71e-12 ad=1.71e-12 \
        ps=4.5e-06 pd=4.5e-06 m=1 region=sat
    \+1127 (517 F2 491 44) ami06N w=9e-07 l=6e-07 as=1.71e-12 ad=1.71e-12 \
        ps=4.5e-06 pd=4.5e-06 m=1 region=sat
    \+1126 (518 F2 492 44) ami06N w=9e-07 l=6e-07 as=1.71e-12 ad=1.71e-12 \
        ps=4.5e-06 pd=4.5e-06 m=1 region=sat
    \+1125 (519 F2 493 44) ami06N w=9e-07 l=6e-07 as=1.71e-12 ad=1.71e-12 \
        ps=4.5e-06 pd=4.5e-06 m=1 region=sat
    \+1124 (520 F2 494 44) ami06N w=9e-07 l=6e-07 as=1.71e-12 ad=1.71e-12 \
        ps=4.5e-06 pd=4.5e-06 m=1 region=sat
    \+1123 (521 F2 495 44) ami06N w=9e-07 l=6e-07 as=1.71e-12 ad=1.71e-12 \
        ps=4.5e-06 pd=4.5e-06 m=1 region=sat
    \+1122 (522 F2 496 44) ami06N w=9e-07 l=6e-07 as=1.71e-12 ad=1.71e-12 \
        ps=4.5e-06 pd=4.5e-06 m=1 region=sat
    \+1121 (523 F2 497 44) ami06N w=9e-07 l=6e-07 as=1.71e-12 ad=1.71e-12 \
        ps=4.5e-06 pd=4.5e-06 m=1 region=sat
    \+1120 (524 F2 498 44) ami06N w=9e-07 l=6e-07 as=1.71e-12 ad=1.71e-12 \
        ps=4.5e-06 pd=4.5e-06 m=1 region=sat
    \+1119 (525 F2 499 44) ami06N w=9e-07 l=6e-07 as=1.71e-12 ad=1.71e-12 \
        ps=4.5e-06 pd=4.5e-06 m=1 region=sat
    \+1118 (526 F2 500 44) ami06N w=9e-07 l=6e-07 as=1.71e-12 ad=1.71e-12 \
        ps=4.5e-06 pd=4.5e-06 m=1 region=sat
    \+1117 (527 F2 501 44) ami06N w=9e-07 l=6e-07 as=1.71e-12 ad=1.71e-12 \
        ps=4.5e-06 pd=4.5e-06 m=1 region=sat
    \+1116 (528 F2 502 44) ami06N w=9e-07 l=6e-07 as=1.71e-12 ad=1.71e-12 \
        ps=4.5e-06 pd=4.5e-06 m=1 region=sat
    \+1115 (529 F2 503 44) ami06N w=9e-07 l=6e-07 as=1.71e-12 ad=1.71e-12 \
        ps=4.5e-06 pd=4.5e-06 m=1 region=sat
    \+1114 (530 F2 504 44) ami06N w=9e-07 l=6e-07 as=1.71e-12 ad=1.71e-12 \
        ps=4.5e-06 pd=4.5e-06 m=1 region=sat
    \+1113 (508 F2 482 44) ami06N w=9e-07 l=6e-07 as=1.71e-12 ad=1.71e-12 \
        ps=4.5e-06 pd=4.5e-06 m=1 region=sat
    \+1112 (531 F2 505 44) ami06N w=9e-07 l=6e-07 as=1.71e-12 ad=1.71e-12 \
        ps=4.5e-06 pd=4.5e-06 m=1 region=sat
    \+1111 (509 F2 483 44) ami06N w=9e-07 l=6e-07 as=1.71e-12 ad=1.71e-12 \
        ps=4.5e-06 pd=4.5e-06 m=1 region=sat
    \+1110 (532 F2 506 44) ami06N w=9e-07 l=6e-07 as=1.71e-12 ad=1.71e-12 \
        ps=4.5e-06 pd=4.5e-06 m=1 region=sat
    \+1109 (487 441 44 44) ami06N w=9e-07 l=6e-07 as=1.71e-12 ad=1.71e-12 \
        ps=4.5e-06 pd=4.5e-06 m=1 region=sat
    \+1108 (488 443 44 44) ami06N w=9e-07 l=6e-07 as=1.71e-12 ad=1.71e-12 \
        ps=4.5e-06 pd=4.5e-06 m=1 region=sat
    \+1107 (489 445 44 44) ami06N w=9e-07 l=6e-07 as=1.71e-12 ad=1.71e-12 \
        ps=4.5e-06 pd=4.5e-06 m=1 region=sat
    \+1106 (490 447 44 44) ami06N w=9e-07 l=6e-07 as=1.71e-12 ad=1.71e-12 \
        ps=4.5e-06 pd=4.5e-06 m=1 region=sat
    \+1105 (491 449 44 44) ami06N w=9e-07 l=6e-07 as=1.71e-12 ad=1.71e-12 \
        ps=4.5e-06 pd=4.5e-06 m=1 region=sat
    \+1104 (492 451 44 44) ami06N w=9e-07 l=6e-07 as=1.71e-12 ad=1.71e-12 \
        ps=4.5e-06 pd=4.5e-06 m=1 region=sat
    \+1103 (493 453 44 44) ami06N w=9e-07 l=6e-07 as=1.71e-12 ad=1.71e-12 \
        ps=4.5e-06 pd=4.5e-06 m=1 region=sat
    \+1102 (494 455 44 44) ami06N w=9e-07 l=6e-07 as=1.71e-12 ad=1.71e-12 \
        ps=4.5e-06 pd=4.5e-06 m=1 region=sat
    \+1101 (495 457 44 44) ami06N w=9e-07 l=6e-07 as=1.71e-12 ad=1.71e-12 \
        ps=4.5e-06 pd=4.5e-06 m=1 region=sat
    \+1100 (496 459 44 44) ami06N w=9e-07 l=6e-07 as=1.71e-12 ad=1.71e-12 \
        ps=4.5e-06 pd=4.5e-06 m=1 region=sat
    \+1099 (497 461 44 44) ami06N w=9e-07 l=6e-07 as=1.71e-12 ad=1.71e-12 \
        ps=4.5e-06 pd=4.5e-06 m=1 region=sat
    \+1098 (498 463 44 44) ami06N w=9e-07 l=6e-07 as=1.71e-12 ad=1.71e-12 \
        ps=4.5e-06 pd=4.5e-06 m=1 region=sat
    \+1097 (499 465 44 44) ami06N w=9e-07 l=6e-07 as=1.71e-12 ad=1.71e-12 \
        ps=4.5e-06 pd=4.5e-06 m=1 region=sat
    \+1096 (500 467 44 44) ami06N w=9e-07 l=6e-07 as=1.71e-12 ad=1.71e-12 \
        ps=4.5e-06 pd=4.5e-06 m=1 region=sat
    \+1095 (501 469 44 44) ami06N w=9e-07 l=6e-07 as=1.71e-12 ad=1.71e-12 \
        ps=4.5e-06 pd=4.5e-06 m=1 region=sat
    \+1094 (502 471 44 44) ami06N w=9e-07 l=6e-07 as=1.71e-12 ad=1.71e-12 \
        ps=4.5e-06 pd=4.5e-06 m=1 region=sat
    \+1093 (503 473 44 44) ami06N w=9e-07 l=6e-07 as=1.71e-12 ad=1.71e-12 \
        ps=4.5e-06 pd=4.5e-06 m=1 region=sat
    \+1092 (504 475 44 44) ami06N w=9e-07 l=6e-07 as=1.71e-12 ad=1.71e-12 \
        ps=4.5e-06 pd=4.5e-06 m=1 region=sat
    \+1091 (482 431 44 44) ami06N w=9e-07 l=6e-07 as=1.71e-12 ad=1.71e-12 \
        ps=4.5e-06 pd=4.5e-06 m=1 region=sat
    \+1090 (505 477 44 44) ami06N w=9e-07 l=6e-07 as=1.71e-12 ad=1.71e-12 \
        ps=4.5e-06 pd=4.5e-06 m=1 region=sat
    \+1089 (483 433 44 44) ami06N w=9e-07 l=6e-07 as=1.71e-12 ad=1.71e-12 \
        ps=4.5e-06 pd=4.5e-06 m=1 region=sat
    \+1088 (506 479 44 44) ami06N w=9e-07 l=6e-07 as=1.71e-12 ad=1.71e-12 \
        ps=4.5e-06 pd=4.5e-06 m=1 region=sat
    \+1087 (484 435 44 44) ami06N w=9e-07 l=6e-07 as=1.71e-12 ad=1.71e-12 \
        ps=4.5e-06 pd=4.5e-06 m=1 region=sat
    \+1086 (507 481 44 44) ami06N w=9e-07 l=6e-07 as=1.71e-12 ad=1.71e-12 \
        ps=4.5e-06 pd=4.5e-06 m=1 region=sat
    \+1085 (485 437 44 44) ami06N w=9e-07 l=6e-07 as=1.71e-12 ad=1.71e-12 \
        ps=4.5e-06 pd=4.5e-06 m=1 region=sat
    \+1084 (486 439 44 44) ami06N w=9e-07 l=6e-07 as=1.71e-12 ad=1.71e-12 \
        ps=4.5e-06 pd=4.5e-06 m=1 region=sat
    \+1083 (44 490 446 44) ami06N w=9e-07 l=6e-07 as=1.71e-12 ad=1.71e-12 \
        ps=4.5e-06 pd=4.5e-06 m=1 region=sat
    \+1082 (44 491 448 44) ami06N w=9e-07 l=6e-07 as=1.71e-12 ad=1.71e-12 \
        ps=4.5e-06 pd=4.5e-06 m=1 region=sat
    \+1081 (44 492 450 44) ami06N w=9e-07 l=6e-07 as=1.71e-12 ad=1.71e-12 \
        ps=4.5e-06 pd=4.5e-06 m=1 region=sat
    \+1080 (44 493 452 44) ami06N w=9e-07 l=6e-07 as=1.71e-12 ad=1.71e-12 \
        ps=4.5e-06 pd=4.5e-06 m=1 region=sat
    \+1079 (44 494 454 44) ami06N w=9e-07 l=6e-07 as=1.71e-12 ad=1.71e-12 \
        ps=4.5e-06 pd=4.5e-06 m=1 region=sat
    \+1078 (44 495 456 44) ami06N w=9e-07 l=6e-07 as=1.71e-12 ad=1.71e-12 \
        ps=4.5e-06 pd=4.5e-06 m=1 region=sat
    \+1077 (44 496 458 44) ami06N w=9e-07 l=6e-07 as=1.71e-12 ad=1.71e-12 \
        ps=4.5e-06 pd=4.5e-06 m=1 region=sat
    \+1076 (44 497 460 44) ami06N w=9e-07 l=6e-07 as=1.71e-12 ad=1.71e-12 \
        ps=4.5e-06 pd=4.5e-06 m=1 region=sat
    \+1075 (44 498 462 44) ami06N w=9e-07 l=6e-07 as=1.71e-12 ad=1.71e-12 \
        ps=4.5e-06 pd=4.5e-06 m=1 region=sat
    \+1074 (44 499 464 44) ami06N w=9e-07 l=6e-07 as=1.71e-12 ad=1.71e-12 \
        ps=4.5e-06 pd=4.5e-06 m=1 region=sat
    \+1073 (44 500 466 44) ami06N w=9e-07 l=6e-07 as=1.71e-12 ad=1.71e-12 \
        ps=4.5e-06 pd=4.5e-06 m=1 region=sat
    \+1072 (44 501 468 44) ami06N w=9e-07 l=6e-07 as=1.71e-12 ad=1.71e-12 \
        ps=4.5e-06 pd=4.5e-06 m=1 region=sat
    \+1071 (44 502 470 44) ami06N w=9e-07 l=6e-07 as=1.71e-12 ad=1.71e-12 \
        ps=4.5e-06 pd=4.5e-06 m=1 region=sat
    \+1070 (44 503 472 44) ami06N w=9e-07 l=6e-07 as=1.71e-12 ad=1.71e-12 \
        ps=4.5e-06 pd=4.5e-06 m=1 region=sat
    \+1069 (44 504 474 44) ami06N w=9e-07 l=6e-07 as=1.71e-12 ad=1.71e-12 \
        ps=4.5e-06 pd=4.5e-06 m=1 region=sat
    \+1068 (44 482 430 44) ami06N w=9e-07 l=6e-07 as=1.71e-12 ad=1.71e-12 \
        ps=4.5e-06 pd=4.5e-06 m=1 region=sat
    \+1067 (44 505 476 44) ami06N w=9e-07 l=6e-07 as=1.71e-12 ad=1.71e-12 \
        ps=4.5e-06 pd=4.5e-06 m=1 region=sat
    \+1066 (44 483 432 44) ami06N w=9e-07 l=6e-07 as=1.71e-12 ad=1.71e-12 \
        ps=4.5e-06 pd=4.5e-06 m=1 region=sat
    \+1065 (44 506 478 44) ami06N w=9e-07 l=6e-07 as=1.71e-12 ad=1.71e-12 \
        ps=4.5e-06 pd=4.5e-06 m=1 region=sat
    \+1064 (44 484 434 44) ami06N w=9e-07 l=6e-07 as=1.71e-12 ad=1.71e-12 \
        ps=4.5e-06 pd=4.5e-06 m=1 region=sat
    \+1063 (44 507 480 44) ami06N w=9e-07 l=6e-07 as=1.71e-12 ad=1.71e-12 \
        ps=4.5e-06 pd=4.5e-06 m=1 region=sat
    \+1062 (44 485 436 44) ami06N w=9e-07 l=6e-07 as=1.71e-12 ad=1.71e-12 \
        ps=4.5e-06 pd=4.5e-06 m=1 region=sat
    \+1061 (44 486 438 44) ami06N w=9e-07 l=6e-07 as=1.71e-12 ad=1.71e-12 \
        ps=4.5e-06 pd=4.5e-06 m=1 region=sat
    \+1060 (44 487 440 44) ami06N w=9e-07 l=6e-07 as=1.71e-12 ad=1.71e-12 \
        ps=4.5e-06 pd=4.5e-06 m=1 region=sat
    \+1059 (44 488 442 44) ami06N w=9e-07 l=6e-07 as=1.71e-12 ad=1.71e-12 \
        ps=4.5e-06 pd=4.5e-06 m=1 region=sat
    \+1058 (44 489 444 44) ami06N w=9e-07 l=6e-07 as=1.71e-12 ad=1.71e-12 \
        ps=4.5e-06 pd=4.5e-06 m=1 region=sat
    \+1005 (405 IR_S0 932 44) ami06N w=9e-07 l=6e-07 as=9.9e-13 \
        ad=1.71e-12 ps=2.1e-06 pd=4.5e-06 m=1 region=sat
    \+1004 (413 PC_S0 955 44) ami06N w=9e-07 l=6e-07 as=9.9e-13 \
        ad=1.71e-12 ps=2.1e-06 pd=4.5e-06 m=1 region=sat
    \+1003 (419 AR_S0B 978 44) ami06N w=9e-07 l=6e-07 as=9.9e-13 \
        ad=1.71e-12 ps=2.1e-06 pd=4.5e-06 m=1 region=sat
    \+1002 (427 OUTP_S0 1001 44) ami06N w=9e-07 l=6e-07 as=9.9e-13 \
        ad=1.71e-12 ps=2.1e-06 pd=4.5e-06 m=1 region=sat
    \+1001 (406 IR_S0 933 44) ami06N w=9e-07 l=6e-07 as=9.9e-13 \
        ad=1.71e-12 ps=2.1e-06 pd=4.5e-06 m=1 region=sat
    \+1000 (413 PC_S0B 956 44) ami06N w=9e-07 l=6e-07 as=9.9e-13 \
        ad=1.71e-12 ps=2.1e-06 pd=4.5e-06 m=1 region=sat
    \+999 (419 AR_S0 979 44) ami06N w=9e-07 l=6e-07 as=9.9e-13 ad=1.71e-12 \
        ps=2.1e-06 pd=4.5e-06 m=1 region=sat
    \+998 (427 OUTP_S0B 1002 44) ami06N w=9e-07 l=6e-07 as=9.9e-13 \
        ad=1.71e-12 ps=2.1e-06 pd=4.5e-06 m=1 region=sat
    \+997 (406 IR_S0B 934 44) ami06N w=9e-07 l=6e-07 as=9.9e-13 \
        ad=1.71e-12 ps=2.1e-06 pd=4.5e-06 m=1 region=sat
    \+996 (413 PC_S0 957 44) ami06N w=9e-07 l=6e-07 as=9.9e-13 ad=1.71e-12 \
        ps=2.1e-06 pd=4.5e-06 m=1 region=sat
    \+995 (420 AR_S0 980 44) ami06N w=9e-07 l=6e-07 as=9.9e-13 ad=1.71e-12 \
        ps=2.1e-06 pd=4.5e-06 m=1 region=sat
    \+994 (427 OUTP_S0 1003 44) ami06N w=9e-07 l=6e-07 as=9.9e-13 \
        ad=1.71e-12 ps=2.1e-06 pd=4.5e-06 m=1 region=sat
    \+993 (406 IR_S0 935 44) ami06N w=9e-07 l=6e-07 as=9.9e-13 ad=1.71e-12 \
        ps=2.1e-06 pd=4.5e-06 m=1 region=sat
    \+992 (413 PC_S0B 958 44) ami06N w=9e-07 l=6e-07 as=9.9e-13 \
        ad=1.71e-12 ps=2.1e-06 pd=4.5e-06 m=1 region=sat
    \+991 (420 AR_S0B 981 44) ami06N w=9e-07 l=6e-07 as=9.9e-13 \
        ad=1.71e-12 ps=2.1e-06 pd=4.5e-06 m=1 region=sat
    \+990 (428 OUTP_S0 1004 44) ami06N w=9e-07 l=6e-07 as=9.9e-13 \
        ad=1.71e-12 ps=2.1e-06 pd=4.5e-06 m=1 region=sat
    \+989 (407 IR_S0 936 44) ami06N w=9e-07 l=6e-07 as=9.9e-13 ad=1.71e-12 \
        ps=2.1e-06 pd=4.5e-06 m=1 region=sat
    \+988 (414 PC_S0 959 44) ami06N w=9e-07 l=6e-07 as=9.9e-13 ad=1.71e-12 \
        ps=2.1e-06 pd=4.5e-06 m=1 region=sat
    \+987 (420 AR_S0 982 44) ami06N w=9e-07 l=6e-07 as=9.9e-13 ad=1.71e-12 \
        ps=2.1e-06 pd=4.5e-06 m=1 region=sat
    \+986 (428 OUTP_S0B 1005 44) ami06N w=9e-07 l=6e-07 as=9.9e-13 \
        ad=1.71e-12 ps=2.1e-06 pd=4.5e-06 m=1 region=sat
    \+985 (407 IR_S0B 937 44) ami06N w=9e-07 l=6e-07 as=9.9e-13 \
        ad=1.71e-12 ps=2.1e-06 pd=4.5e-06 m=1 region=sat
    \+984 (414 PC_S0B 960 44) ami06N w=9e-07 l=6e-07 as=9.9e-13 \
        ad=1.71e-12 ps=2.1e-06 pd=4.5e-06 m=1 region=sat
    \+983 (421 AR_S0 983 44) ami06N w=9e-07 l=6e-07 as=9.9e-13 ad=1.71e-12 \
        ps=2.1e-06 pd=4.5e-06 m=1 region=sat
    \+982 (428 OUTP_S0 1006 44) ami06N w=9e-07 l=6e-07 as=9.9e-13 \
        ad=1.71e-12 ps=2.1e-06 pd=4.5e-06 m=1 region=sat
    \+981 (407 IR_S0 938 44) ami06N w=9e-07 l=6e-07 as=9.9e-13 ad=1.71e-12 \
        ps=2.1e-06 pd=4.5e-06 m=1 region=sat
    \+980 (414 PC_S0 961 44) ami06N w=9e-07 l=6e-07 as=9.9e-13 ad=1.71e-12 \
        ps=2.1e-06 pd=4.5e-06 m=1 region=sat
    \+979 (421 AR_S0B 984 44) ami06N w=9e-07 l=6e-07 as=9.9e-13 \
        ad=1.71e-12 ps=2.1e-06 pd=4.5e-06 m=1 region=sat
    \+978 (429 OUTP_S0 1007 44) ami06N w=9e-07 l=6e-07 as=9.9e-13 \
        ad=1.71e-12 ps=2.1e-06 pd=4.5e-06 m=1 region=sat
    \+977 (408 IR_S0 939 44) ami06N w=9e-07 l=6e-07 as=9.9e-13 ad=1.71e-12 \
        ps=2.1e-06 pd=4.5e-06 m=1 region=sat
    \+976 (414 PC_S0B 962 44) ami06N w=9e-07 l=6e-07 as=9.9e-13 \
        ad=1.71e-12 ps=2.1e-06 pd=4.5e-06 m=1 region=sat
    \+975 (421 AR_S0 985 44) ami06N w=9e-07 l=6e-07 as=9.9e-13 ad=1.71e-12 \
        ps=2.1e-06 pd=4.5e-06 m=1 region=sat
    \+974 (429 OUTP_S0B 1008 44) ami06N w=9e-07 l=6e-07 as=9.9e-13 \
        ad=1.71e-12 ps=2.1e-06 pd=4.5e-06 m=1 region=sat
    \+973 (408 IR_S0B 940 44) ami06N w=9e-07 l=6e-07 as=9.9e-13 \
        ad=1.71e-12 ps=2.1e-06 pd=4.5e-06 m=1 region=sat
    \+972 (415 PC_S0 963 44) ami06N w=9e-07 l=6e-07 as=9.9e-13 ad=1.71e-12 \
        ps=2.1e-06 pd=4.5e-06 m=1 region=sat
    \+971 (422 OUTP_S0 986 44) ami06N w=9e-07 l=6e-07 as=9.9e-13 \
        ad=1.71e-12 ps=2.1e-06 pd=4.5e-06 m=1 region=sat
    \+970 (429 OUTP_S0 1009 44) ami06N w=9e-07 l=6e-07 as=9.9e-13 \
        ad=1.71e-12 ps=2.1e-06 pd=4.5e-06 m=1 region=sat
    \+969 (408 IR_S0 941 44) ami06N w=9e-07 l=6e-07 as=9.9e-13 ad=1.71e-12 \
        ps=2.1e-06 pd=4.5e-06 m=1 region=sat
    \+968 (415 PC_S0B 964 44) ami06N w=9e-07 l=6e-07 as=9.9e-13 \
        ad=1.71e-12 ps=2.1e-06 pd=4.5e-06 m=1 region=sat
    \+967 (422 OUTP_S0B 987 44) ami06N w=9e-07 l=6e-07 as=9.9e-13 \
        ad=1.71e-12 ps=2.1e-06 pd=4.5e-06 m=1 region=sat
    \+966 (409 IR_S0 942 44) ami06N w=9e-07 l=6e-07 as=9.9e-13 ad=1.71e-12 \
        ps=2.1e-06 pd=4.5e-06 m=1 region=sat
    \+965 (415 PC_S0 965 44) ami06N w=9e-07 l=6e-07 as=9.9e-13 ad=1.71e-12 \
        ps=2.1e-06 pd=4.5e-06 m=1 region=sat
    \+964 (422 OUTP_S0 988 44) ami06N w=9e-07 l=6e-07 as=9.9e-13 \
        ad=1.71e-12 ps=2.1e-06 pd=4.5e-06 m=1 region=sat
    \+963 (409 IR_S0B 943 44) ami06N w=9e-07 l=6e-07 as=9.9e-13 \
        ad=1.71e-12 ps=2.1e-06 pd=4.5e-06 m=1 region=sat
    \+962 (415 PC_S0B 966 44) ami06N w=9e-07 l=6e-07 as=9.9e-13 \
        ad=1.71e-12 ps=2.1e-06 pd=4.5e-06 m=1 region=sat
    \+961 (423 OUTP_S0 989 44) ami06N w=9e-07 l=6e-07 as=9.9e-13 \
        ad=1.71e-12 ps=2.1e-06 pd=4.5e-06 m=1 region=sat
    \+960 (409 IR_S0 944 44) ami06N w=9e-07 l=6e-07 as=9.9e-13 ad=1.71e-12 \
        ps=2.1e-06 pd=4.5e-06 m=1 region=sat
    \+959 (416 PC_S0 967 44) ami06N w=9e-07 l=6e-07 as=9.9e-13 ad=1.71e-12 \
        ps=2.1e-06 pd=4.5e-06 m=1 region=sat
    \+958 (423 OUTP_S0B 990 44) ami06N w=9e-07 l=6e-07 as=9.9e-13 \
        ad=1.71e-12 ps=2.1e-06 pd=4.5e-06 m=1 region=sat
    \+957 (410 IR_S0 945 44) ami06N w=9e-07 l=6e-07 as=9.9e-13 ad=1.71e-12 \
        ps=2.1e-06 pd=4.5e-06 m=1 region=sat
    \+956 (416 PC_S0B 968 44) ami06N w=9e-07 l=6e-07 as=9.9e-13 \
        ad=1.71e-12 ps=2.1e-06 pd=4.5e-06 m=1 region=sat
    \+955 (423 OUTP_S0 991 44) ami06N w=9e-07 l=6e-07 as=9.9e-13 \
        ad=1.71e-12 ps=2.1e-06 pd=4.5e-06 m=1 region=sat
    \+954 (410 IR_S0B 946 44) ami06N w=9e-07 l=6e-07 as=9.9e-13 \
        ad=1.71e-12 ps=2.1e-06 pd=4.5e-06 m=1 region=sat
    \+953 (416 PC_S0 969 44) ami06N w=9e-07 l=6e-07 as=9.9e-13 ad=1.71e-12 \
        ps=2.1e-06 pd=4.5e-06 m=1 region=sat
    \+952 (424 OUTP_S0 992 44) ami06N w=9e-07 l=6e-07 as=9.9e-13 \
        ad=1.71e-12 ps=2.1e-06 pd=4.5e-06 m=1 region=sat
    \+951 (410 IR_S0 947 44) ami06N w=9e-07 l=6e-07 as=9.9e-13 ad=1.71e-12 \
        ps=2.1e-06 pd=4.5e-06 m=1 region=sat
    \+950 (416 PC_S0B 970 44) ami06N w=9e-07 l=6e-07 as=9.9e-13 \
        ad=1.71e-12 ps=2.1e-06 pd=4.5e-06 m=1 region=sat
    \+949 (424 OUTP_S0B 993 44) ami06N w=9e-07 l=6e-07 as=9.9e-13 \
        ad=1.71e-12 ps=2.1e-06 pd=4.5e-06 m=1 region=sat
    \+948 (411 IR_S0 948 44) ami06N w=9e-07 l=6e-07 as=9.9e-13 ad=1.71e-12 \
        ps=2.1e-06 pd=4.5e-06 m=1 region=sat
    \+947 (417 AR_S0 971 44) ami06N w=9e-07 l=6e-07 as=9.9e-13 ad=1.71e-12 \
        ps=2.1e-06 pd=4.5e-06 m=1 region=sat
    \+946 (424 OUTP_S0 994 44) ami06N w=9e-07 l=6e-07 as=9.9e-13 \
        ad=1.71e-12 ps=2.1e-06 pd=4.5e-06 m=1 region=sat
    \+945 (411 IR_S0B 949 44) ami06N w=9e-07 l=6e-07 as=9.9e-13 \
        ad=1.71e-12 ps=2.1e-06 pd=4.5e-06 m=1 region=sat
    \+944 (417 AR_S0B 972 44) ami06N w=9e-07 l=6e-07 as=9.9e-13 \
        ad=1.71e-12 ps=2.1e-06 pd=4.5e-06 m=1 region=sat
    \+943 (425 OUTP_S0 995 44) ami06N w=9e-07 l=6e-07 as=9.9e-13 \
        ad=1.71e-12 ps=2.1e-06 pd=4.5e-06 m=1 region=sat
    \+942 (404 IR_S0 927 44) ami06N w=9e-07 l=6e-07 as=9.9e-13 ad=1.71e-12 \
        ps=2.1e-06 pd=4.5e-06 m=1 region=sat
    \+941 (411 IR_S0 950 44) ami06N w=9e-07 l=6e-07 as=9.9e-13 ad=1.71e-12 \
        ps=2.1e-06 pd=4.5e-06 m=1 region=sat
    \+940 (417 AR_S0 973 44) ami06N w=9e-07 l=6e-07 as=9.9e-13 ad=1.71e-12 \
        ps=2.1e-06 pd=4.5e-06 m=1 region=sat
    \+939 (425 OUTP_S0B 996 44) ami06N w=9e-07 l=6e-07 as=9.9e-13 \
        ad=1.71e-12 ps=2.1e-06 pd=4.5e-06 m=1 region=sat
    \+938 (404 IR_S0B 928 44) ami06N w=9e-07 l=6e-07 as=9.9e-13 \
        ad=1.71e-12 ps=2.1e-06 pd=4.5e-06 m=1 region=sat
    \+937 (412 PC_S0 951 44) ami06N w=9e-07 l=6e-07 as=9.9e-13 ad=1.71e-12 \
        ps=2.1e-06 pd=4.5e-06 m=1 region=sat
    \+936 (418 AR_S0 974 44) ami06N w=9e-07 l=6e-07 as=9.9e-13 ad=1.71e-12 \
        ps=2.1e-06 pd=4.5e-06 m=1 region=sat
    \+935 (425 OUTP_S0 997 44) ami06N w=9e-07 l=6e-07 as=9.9e-13 \
        ad=1.71e-12 ps=2.1e-06 pd=4.5e-06 m=1 region=sat
    \+934 (404 IR_S0 929 44) ami06N w=9e-07 l=6e-07 as=9.9e-13 ad=1.71e-12 \
        ps=2.1e-06 pd=4.5e-06 m=1 region=sat
    \+933 (412 PC_S0B 952 44) ami06N w=9e-07 l=6e-07 as=9.9e-13 \
        ad=1.71e-12 ps=2.1e-06 pd=4.5e-06 m=1 region=sat
    \+932 (418 AR_S0B 975 44) ami06N w=9e-07 l=6e-07 as=9.9e-13 \
        ad=1.71e-12 ps=2.1e-06 pd=4.5e-06 m=1 region=sat
    \+931 (426 OUTP_S0 998 44) ami06N w=9e-07 l=6e-07 as=9.9e-13 \
        ad=1.71e-12 ps=2.1e-06 pd=4.5e-06 m=1 region=sat
    \+930 (405 IR_S0 930 44) ami06N w=9e-07 l=6e-07 as=9.9e-13 ad=1.71e-12 \
        ps=2.1e-06 pd=4.5e-06 m=1 region=sat
    \+929 (412 PC_S0 953 44) ami06N w=9e-07 l=6e-07 as=9.9e-13 ad=1.71e-12 \
        ps=2.1e-06 pd=4.5e-06 m=1 region=sat
    \+928 (418 AR_S0 976 44) ami06N w=9e-07 l=6e-07 as=9.9e-13 ad=1.71e-12 \
        ps=2.1e-06 pd=4.5e-06 m=1 region=sat
    \+927 (426 OUTP_S0B 999 44) ami06N w=9e-07 l=6e-07 as=9.9e-13 \
        ad=1.71e-12 ps=2.1e-06 pd=4.5e-06 m=1 region=sat
    \+926 (405 IR_S0B 931 44) ami06N w=9e-07 l=6e-07 as=9.9e-13 \
        ad=1.71e-12 ps=2.1e-06 pd=4.5e-06 m=1 region=sat
    \+925 (412 PC_S0B 954 44) ami06N w=9e-07 l=6e-07 as=9.9e-13 \
        ad=1.71e-12 ps=2.1e-06 pd=4.5e-06 m=1 region=sat
    \+924 (419 AR_S0 977 44) ami06N w=9e-07 l=6e-07 as=9.9e-13 ad=1.71e-12 \
        ps=2.1e-06 pd=4.5e-06 m=1 region=sat
    \+923 (426 OUTP_S0 1000 44) ami06N w=9e-07 l=6e-07 as=9.9e-13 \
        ad=1.71e-12 ps=2.1e-06 pd=4.5e-06 m=1 region=sat
    \+922 (946 IR_S1 Memory\<6\> 44) ami06N w=9e-07 l=6e-07 as=1.71e-12 \
        ad=9.9e-13 ps=4.5e-06 pd=2.1e-06 m=1 region=sat
    \+921 (969 PC_S1B 44 44) ami06N w=9e-07 l=6e-07 as=1.71e-12 ad=9.9e-13 \
        ps=4.5e-06 pd=2.1e-06 m=1 region=sat
    \+920 (992 OUTP_S1 398 44) ami06N w=9e-07 l=6e-07 as=1.71e-12 \
        ad=9.9e-13 ps=4.5e-06 pd=2.1e-06 m=1 region=sat
    \+919 (947 IR_S1B 44 44) ami06N w=9e-07 l=6e-07 as=1.71e-12 ad=9.9e-13 \
        ps=4.5e-06 pd=2.1e-06 m=1 region=sat
    \+918 (970 PC_S1B 390 44) ami06N w=9e-07 l=6e-07 as=1.71e-12 \
        ad=9.9e-13 ps=4.5e-06 pd=2.1e-06 m=1 region=sat
    \+917 (993 OUTP_S1 Memory\<2\> 44) ami06N w=9e-07 l=6e-07 as=1.71e-12 \
        ad=9.9e-13 ps=4.5e-06 pd=2.1e-06 m=1 region=sat
    \+916 (948 IR_S1 380 44) ami06N w=9e-07 l=6e-07 as=1.71e-12 ad=9.9e-13 \
        ps=4.5e-06 pd=2.1e-06 m=1 region=sat
    \+915 (971 AR_S1 391 44) ami06N w=9e-07 l=6e-07 as=1.71e-12 ad=9.9e-13 \
        ps=4.5e-06 pd=2.1e-06 m=1 region=sat
    \+914 (994 OUTP_S1B 44 44) ami06N w=9e-07 l=6e-07 as=1.71e-12 \
        ad=9.9e-13 ps=4.5e-06 pd=2.1e-06 m=1 region=sat
    \+913 (949 IR_S1 Memory\<7\> 44) ami06N w=9e-07 l=6e-07 as=1.71e-12 \
        ad=9.9e-13 ps=4.5e-06 pd=2.1e-06 m=1 region=sat
    \+912 (972 AR_S1 Memory\<0\> 44) ami06N w=9e-07 l=6e-07 as=1.71e-12 \
        ad=9.9e-13 ps=4.5e-06 pd=2.1e-06 m=1 region=sat
    \+911 (995 OUTP_S1 399 44) ami06N w=9e-07 l=6e-07 as=1.71e-12 \
        ad=9.9e-13 ps=4.5e-06 pd=2.1e-06 m=1 region=sat
    \+910 (927 IR_S1 373 44) ami06N w=9e-07 l=6e-07 as=1.71e-12 ad=9.9e-13 \
        ps=4.5e-06 pd=2.1e-06 m=1 region=sat
    \+909 (950 IR_S1B 44 44) ami06N w=9e-07 l=6e-07 as=1.71e-12 ad=9.9e-13 \
        ps=4.5e-06 pd=2.1e-06 m=1 region=sat
    \+908 (973 AR_S1B 44 44) ami06N w=9e-07 l=6e-07 as=1.71e-12 ad=9.9e-13 \
        ps=4.5e-06 pd=2.1e-06 m=1 region=sat
    \+907 (996 OUTP_S1 Memory\<3\> 44) ami06N w=9e-07 l=6e-07 as=1.71e-12 \
        ad=9.9e-13 ps=4.5e-06 pd=2.1e-06 m=1 region=sat
    \+906 (928 IR_S1 Memory\<0\> 44) ami06N w=9e-07 l=6e-07 as=1.71e-12 \
        ad=9.9e-13 ps=4.5e-06 pd=2.1e-06 m=1 region=sat
    \+905 (951 PC_S1 381 44) ami06N w=9e-07 l=6e-07 as=1.71e-12 ad=9.9e-13 \
        ps=4.5e-06 pd=2.1e-06 m=1 region=sat
    \+904 (974 AR_S1 392 44) ami06N w=9e-07 l=6e-07 as=1.71e-12 ad=9.9e-13 \
        ps=4.5e-06 pd=2.1e-06 m=1 region=sat
    \+903 (997 OUTP_S1B 44 44) ami06N w=9e-07 l=6e-07 as=1.71e-12 \
        ad=9.9e-13 ps=4.5e-06 pd=2.1e-06 m=1 region=sat
    \+902 (929 IR_S1B 44 44) ami06N w=9e-07 l=6e-07 as=1.71e-12 ad=9.9e-13 \
        ps=4.5e-06 pd=2.1e-06 m=1 region=sat
    \+901 (952 PC_S1 Memory\<0\> 44) ami06N w=9e-07 l=6e-07 as=1.71e-12 \
        ad=9.9e-13 ps=4.5e-06 pd=2.1e-06 m=1 region=sat
    \+900 (975 AR_S1 Memory\<1\> 44) ami06N w=9e-07 l=6e-07 as=1.71e-12 \
        ad=9.9e-13 ps=4.5e-06 pd=2.1e-06 m=1 region=sat
    \+899 (998 OUTP_S1 400 44) ami06N w=9e-07 l=6e-07 as=1.71e-12 \
        ad=9.9e-13 ps=4.5e-06 pd=2.1e-06 m=1 region=sat
    \+898 (930 IR_S1 374 44) ami06N w=9e-07 l=6e-07 as=1.71e-12 ad=9.9e-13 \
        ps=4.5e-06 pd=2.1e-06 m=1 region=sat
    \+897 (953 PC_S1B 44 44) ami06N w=9e-07 l=6e-07 as=1.71e-12 ad=9.9e-13 \
        ps=4.5e-06 pd=2.1e-06 m=1 region=sat
    \+896 (976 AR_S1B 44 44) ami06N w=9e-07 l=6e-07 as=1.71e-12 ad=9.9e-13 \
        ps=4.5e-06 pd=2.1e-06 m=1 region=sat
    \+895 (999 OUTP_S1 Memory\<4\> 44) ami06N w=9e-07 l=6e-07 as=1.71e-12 \
        ad=9.9e-13 ps=4.5e-06 pd=2.1e-06 m=1 region=sat
    \+894 (931 IR_S1 Memory\<1\> 44) ami06N w=9e-07 l=6e-07 as=1.71e-12 \
        ad=9.9e-13 ps=4.5e-06 pd=2.1e-06 m=1 region=sat
    \+893 (954 PC_S1B 382 44) ami06N w=9e-07 l=6e-07 as=1.71e-12 \
        ad=9.9e-13 ps=4.5e-06 pd=2.1e-06 m=1 region=sat
    \+892 (977 AR_S1 393 44) ami06N w=9e-07 l=6e-07 as=1.71e-12 ad=9.9e-13 \
        ps=4.5e-06 pd=2.1e-06 m=1 region=sat
    \+891 (1000 OUTP_S1B 44 44) ami06N w=9e-07 l=6e-07 as=1.71e-12 \
        ad=9.9e-13 ps=4.5e-06 pd=2.1e-06 m=1 region=sat
    \+890 (932 IR_S1B 44 44) ami06N w=9e-07 l=6e-07 as=1.71e-12 ad=9.9e-13 \
        ps=4.5e-06 pd=2.1e-06 m=1 region=sat
    \+889 (955 PC_S1 383 44) ami06N w=9e-07 l=6e-07 as=1.71e-12 ad=9.9e-13 \
        ps=4.5e-06 pd=2.1e-06 m=1 region=sat
    \+888 (978 AR_S1 Memory\<2\> 44) ami06N w=9e-07 l=6e-07 as=1.71e-12 \
        ad=9.9e-13 ps=4.5e-06 pd=2.1e-06 m=1 region=sat
    \+887 (1001 OUTP_S1 401 44) ami06N w=9e-07 l=6e-07 as=1.71e-12 \
        ad=9.9e-13 ps=4.5e-06 pd=2.1e-06 m=1 region=sat
    \+886 (933 IR_S1 375 44) ami06N w=9e-07 l=6e-07 as=1.71e-12 ad=9.9e-13 \
        ps=4.5e-06 pd=2.1e-06 m=1 region=sat
    \+885 (956 PC_S1 Memory\<1\> 44) ami06N w=9e-07 l=6e-07 as=1.71e-12 \
        ad=9.9e-13 ps=4.5e-06 pd=2.1e-06 m=1 region=sat
    \+884 (979 AR_S1B 44 44) ami06N w=9e-07 l=6e-07 as=1.71e-12 ad=9.9e-13 \
        ps=4.5e-06 pd=2.1e-06 m=1 region=sat
    \+883 (1002 OUTP_S1 Memory\<5\> 44) ami06N w=9e-07 l=6e-07 as=1.71e-12 \
        ad=9.9e-13 ps=4.5e-06 pd=2.1e-06 m=1 region=sat
    \+882 (934 IR_S1 Memory\<2\> 44) ami06N w=9e-07 l=6e-07 as=1.71e-12 \
        ad=9.9e-13 ps=4.5e-06 pd=2.1e-06 m=1 region=sat
    \+881 (957 PC_S1B 44 44) ami06N w=9e-07 l=6e-07 as=1.71e-12 ad=9.9e-13 \
        ps=4.5e-06 pd=2.1e-06 m=1 region=sat
    \+880 (980 AR_S1 394 44) ami06N w=9e-07 l=6e-07 as=1.71e-12 ad=9.9e-13 \
        ps=4.5e-06 pd=2.1e-06 m=1 region=sat
    \+879 (1003 OUTP_S1B 44 44) ami06N w=9e-07 l=6e-07 as=1.71e-12 \
        ad=9.9e-13 ps=4.5e-06 pd=2.1e-06 m=1 region=sat
    \+878 (935 IR_S1B 44 44) ami06N w=9e-07 l=6e-07 as=1.71e-12 ad=9.9e-13 \
        ps=4.5e-06 pd=2.1e-06 m=1 region=sat
    \+877 (958 PC_S1B 384 44) ami06N w=9e-07 l=6e-07 as=1.71e-12 \
        ad=9.9e-13 ps=4.5e-06 pd=2.1e-06 m=1 region=sat
    \+876 (981 AR_S1 Memory\<3\> 44) ami06N w=9e-07 l=6e-07 as=1.71e-12 \
        ad=9.9e-13 ps=4.5e-06 pd=2.1e-06 m=1 region=sat
    \+875 (1004 OUTP_S1 402 44) ami06N w=9e-07 l=6e-07 as=1.71e-12 \
        ad=9.9e-13 ps=4.5e-06 pd=2.1e-06 m=1 region=sat
    \+874 (936 IR_S1 376 44) ami06N w=9e-07 l=6e-07 as=1.71e-12 ad=9.9e-13 \
        ps=4.5e-06 pd=2.1e-06 m=1 region=sat
    \+873 (959 PC_S1 385 44) ami06N w=9e-07 l=6e-07 as=1.71e-12 ad=9.9e-13 \
        ps=4.5e-06 pd=2.1e-06 m=1 region=sat
    \+872 (982 AR_S1B 44 44) ami06N w=9e-07 l=6e-07 as=1.71e-12 ad=9.9e-13 \
        ps=4.5e-06 pd=2.1e-06 m=1 region=sat
    \+871 (1005 OUTP_S1 Memory\<6\> 44) ami06N w=9e-07 l=6e-07 as=1.71e-12 \
        ad=9.9e-13 ps=4.5e-06 pd=2.1e-06 m=1 region=sat
    \+870 (937 IR_S1 Memory\<3\> 44) ami06N w=9e-07 l=6e-07 as=1.71e-12 \
        ad=9.9e-13 ps=4.5e-06 pd=2.1e-06 m=1 region=sat
    \+869 (960 PC_S1 Memory\<2\> 44) ami06N w=9e-07 l=6e-07 as=1.71e-12 \
        ad=9.9e-13 ps=4.5e-06 pd=2.1e-06 m=1 region=sat
    \+868 (983 AR_S1 395 44) ami06N w=9e-07 l=6e-07 as=1.71e-12 ad=9.9e-13 \
        ps=4.5e-06 pd=2.1e-06 m=1 region=sat
    \+867 (1006 OUTP_S1B 44 44) ami06N w=9e-07 l=6e-07 as=1.71e-12 \
        ad=9.9e-13 ps=4.5e-06 pd=2.1e-06 m=1 region=sat
    \+866 (938 IR_S1B 44 44) ami06N w=9e-07 l=6e-07 as=1.71e-12 ad=9.9e-13 \
        ps=4.5e-06 pd=2.1e-06 m=1 region=sat
    \+865 (961 PC_S1B 44 44) ami06N w=9e-07 l=6e-07 as=1.71e-12 ad=9.9e-13 \
        ps=4.5e-06 pd=2.1e-06 m=1 region=sat
    \+864 (984 AR_S1 Memory\<4\> 44) ami06N w=9e-07 l=6e-07 as=1.71e-12 \
        ad=9.9e-13 ps=4.5e-06 pd=2.1e-06 m=1 region=sat
    \+863 (1007 OUTP_S1 403 44) ami06N w=9e-07 l=6e-07 as=1.71e-12 \
        ad=9.9e-13 ps=4.5e-06 pd=2.1e-06 m=1 region=sat
    \+862 (939 IR_S1 377 44) ami06N w=9e-07 l=6e-07 as=1.71e-12 ad=9.9e-13 \
        ps=4.5e-06 pd=2.1e-06 m=1 region=sat
    \+861 (962 PC_S1B 386 44) ami06N w=9e-07 l=6e-07 as=1.71e-12 \
        ad=9.9e-13 ps=4.5e-06 pd=2.1e-06 m=1 region=sat
    \+860 (985 AR_S1B 44 44) ami06N w=9e-07 l=6e-07 as=1.71e-12 ad=9.9e-13 \
        ps=4.5e-06 pd=2.1e-06 m=1 region=sat
    \+859 (1008 OUTP_S1 Memory\<7\> 44) ami06N w=9e-07 l=6e-07 as=1.71e-12 \
        ad=9.9e-13 ps=4.5e-06 pd=2.1e-06 m=1 region=sat
    \+858 (940 IR_S1 Memory\<4\> 44) ami06N w=9e-07 l=6e-07 as=1.71e-12 \
        ad=9.9e-13 ps=4.5e-06 pd=2.1e-06 m=1 region=sat
    \+857 (963 PC_S1 387 44) ami06N w=9e-07 l=6e-07 as=1.71e-12 ad=9.9e-13 \
        ps=4.5e-06 pd=2.1e-06 m=1 region=sat
    \+856 (986 OUTP_S1 396 44) ami06N w=9e-07 l=6e-07 as=1.71e-12 \
        ad=9.9e-13 ps=4.5e-06 pd=2.1e-06 m=1 region=sat
    \+855 (1009 OUTP_S1B 44 44) ami06N w=9e-07 l=6e-07 as=1.71e-12 \
        ad=9.9e-13 ps=4.5e-06 pd=2.1e-06 m=1 region=sat
    \+854 (941 IR_S1B 44 44) ami06N w=9e-07 l=6e-07 as=1.71e-12 ad=9.9e-13 \
        ps=4.5e-06 pd=2.1e-06 m=1 region=sat
    \+853 (964 PC_S1 Memory\<3\> 44) ami06N w=9e-07 l=6e-07 as=1.71e-12 \
        ad=9.9e-13 ps=4.5e-06 pd=2.1e-06 m=1 region=sat
    \+852 (987 OUTP_S1 Memory\<0\> 44) ami06N w=9e-07 l=6e-07 as=1.71e-12 \
        ad=9.9e-13 ps=4.5e-06 pd=2.1e-06 m=1 region=sat
    \+851 (942 IR_S1 378 44) ami06N w=9e-07 l=6e-07 as=1.71e-12 ad=9.9e-13 \
        ps=4.5e-06 pd=2.1e-06 m=1 region=sat
    \+850 (965 PC_S1B 44 44) ami06N w=9e-07 l=6e-07 as=1.71e-12 ad=9.9e-13 \
        ps=4.5e-06 pd=2.1e-06 m=1 region=sat
    \+849 (988 OUTP_S1B 44 44) ami06N w=9e-07 l=6e-07 as=1.71e-12 \
        ad=9.9e-13 ps=4.5e-06 pd=2.1e-06 m=1 region=sat
    \+848 (943 IR_S1 Memory\<5\> 44) ami06N w=9e-07 l=6e-07 as=1.71e-12 \
        ad=9.9e-13 ps=4.5e-06 pd=2.1e-06 m=1 region=sat
    \+847 (966 PC_S1B 388 44) ami06N w=9e-07 l=6e-07 as=1.71e-12 \
        ad=9.9e-13 ps=4.5e-06 pd=2.1e-06 m=1 region=sat
    \+846 (989 OUTP_S1 397 44) ami06N w=9e-07 l=6e-07 as=1.71e-12 \
        ad=9.9e-13 ps=4.5e-06 pd=2.1e-06 m=1 region=sat
    \+845 (944 IR_S1B 44 44) ami06N w=9e-07 l=6e-07 as=1.71e-12 ad=9.9e-13 \
        ps=4.5e-06 pd=2.1e-06 m=1 region=sat
    \+844 (967 PC_S1 389 44) ami06N w=9e-07 l=6e-07 as=1.71e-12 ad=9.9e-13 \
        ps=4.5e-06 pd=2.1e-06 m=1 region=sat
    \+843 (990 OUTP_S1 Memory\<1\> 44) ami06N w=9e-07 l=6e-07 as=1.71e-12 \
        ad=9.9e-13 ps=4.5e-06 pd=2.1e-06 m=1 region=sat
    \+842 (945 IR_S1 379 44) ami06N w=9e-07 l=6e-07 as=1.71e-12 ad=9.9e-13 \
        ps=4.5e-06 pd=2.1e-06 m=1 region=sat
    \+841 (968 PC_S1 Memory\<4\> 44) ami06N w=9e-07 l=6e-07 as=1.71e-12 \
        ad=9.9e-13 ps=4.5e-06 pd=2.1e-06 m=1 region=sat
    \+840 (991 OUTP_S1B 44 44) ami06N w=9e-07 l=6e-07 as=1.71e-12 \
        ad=9.9e-13 ps=4.5e-06 pd=2.1e-06 m=1 region=sat
    \+823 (Memory\<4\> DR_S1 916 44) ami06N w=9e-07 l=6e-07 as=9.9e-13 \
        ad=1.71e-12 ps=2.1e-06 pd=4.5e-06 m=1 region=sat
    \+822 (44 DR_S1B 917 44) ami06N w=9e-07 l=6e-07 as=9.9e-13 ad=1.71e-12 \
        ps=2.1e-06 pd=4.5e-06 m=1 region=sat
    \+821 (226 DR_S1 918 44) ami06N w=9e-07 l=6e-07 as=9.9e-13 ad=1.71e-12 \
        ps=2.1e-06 pd=4.5e-06 m=1 region=sat
    \+820 (Memory\<5\> DR_S1 919 44) ami06N w=9e-07 l=6e-07 as=9.9e-13 \
        ad=1.71e-12 ps=2.1e-06 pd=4.5e-06 m=1 region=sat
    \+819 (44 DR_S1B 920 44) ami06N w=9e-07 l=6e-07 as=9.9e-13 ad=1.71e-12 \
        ps=2.1e-06 pd=4.5e-06 m=1 region=sat
    \+818 (227 DR_S1 921 44) ami06N w=9e-07 l=6e-07 as=9.9e-13 ad=1.71e-12 \
        ps=2.1e-06 pd=4.5e-06 m=1 region=sat
    \+817 (Memory\<6\> DR_S1 922 44) ami06N w=9e-07 l=6e-07 as=9.9e-13 \
        ad=1.71e-12 ps=2.1e-06 pd=4.5e-06 m=1 region=sat
    \+816 (44 DR_S1B 923 44) ami06N w=9e-07 l=6e-07 as=9.9e-13 ad=1.71e-12 \
        ps=2.1e-06 pd=4.5e-06 m=1 region=sat
    \+815 (228 DR_S1 924 44) ami06N w=9e-07 l=6e-07 as=9.9e-13 ad=1.71e-12 \
        ps=2.1e-06 pd=4.5e-06 m=1 region=sat
    \+814 (Memory\<7\> DR_S1 925 44) ami06N w=9e-07 l=6e-07 as=9.9e-13 \
        ad=1.71e-12 ps=2.1e-06 pd=4.5e-06 m=1 region=sat
    \+813 (221 DR_S1 903 44) ami06N w=9e-07 l=6e-07 as=9.9e-13 ad=1.71e-12 \
        ps=2.1e-06 pd=4.5e-06 m=1 region=sat
    \+812 (44 DR_S1B 926 44) ami06N w=9e-07 l=6e-07 as=9.9e-13 ad=1.71e-12 \
        ps=2.1e-06 pd=4.5e-06 m=1 region=sat
    \+811 (Memory\<0\> DR_S1 904 44) ami06N w=9e-07 l=6e-07 as=9.9e-13 \
        ad=1.71e-12 ps=2.1e-06 pd=4.5e-06 m=1 region=sat
    \+810 (44 DR_S1B 905 44) ami06N w=9e-07 l=6e-07 as=9.9e-13 ad=1.71e-12 \
        ps=2.1e-06 pd=4.5e-06 m=1 region=sat
    \+809 (222 DR_S1 906 44) ami06N w=9e-07 l=6e-07 as=9.9e-13 ad=1.71e-12 \
        ps=2.1e-06 pd=4.5e-06 m=1 region=sat
    \+808 (Memory\<1\> DR_S1 907 44) ami06N w=9e-07 l=6e-07 as=9.9e-13 \
        ad=1.71e-12 ps=2.1e-06 pd=4.5e-06 m=1 region=sat
    \+807 (44 DR_S1B 908 44) ami06N w=9e-07 l=6e-07 as=9.9e-13 ad=1.71e-12 \
        ps=2.1e-06 pd=4.5e-06 m=1 region=sat
    \+806 (223 DR_S1 909 44) ami06N w=9e-07 l=6e-07 as=9.9e-13 ad=1.71e-12 \
        ps=2.1e-06 pd=4.5e-06 m=1 region=sat
    \+805 (Memory\<2\> DR_S1 910 44) ami06N w=9e-07 l=6e-07 as=9.9e-13 \
        ad=1.71e-12 ps=2.1e-06 pd=4.5e-06 m=1 region=sat
    \+804 (44 DR_S1B 911 44) ami06N w=9e-07 l=6e-07 as=9.9e-13 ad=1.71e-12 \
        ps=2.1e-06 pd=4.5e-06 m=1 region=sat
    \+803 (224 DR_S1 912 44) ami06N w=9e-07 l=6e-07 as=9.9e-13 ad=1.71e-12 \
        ps=2.1e-06 pd=4.5e-06 m=1 region=sat
    \+802 (Memory\<3\> DR_S1 913 44) ami06N w=9e-07 l=6e-07 as=9.9e-13 \
        ad=1.71e-12 ps=2.1e-06 pd=4.5e-06 m=1 region=sat
    \+801 (44 DR_S1B 914 44) ami06N w=9e-07 l=6e-07 as=9.9e-13 ad=1.71e-12 \
        ps=2.1e-06 pd=4.5e-06 m=1 region=sat
    \+800 (225 DR_S1 915 44) ami06N w=9e-07 l=6e-07 as=9.9e-13 ad=1.71e-12 \
        ps=2.1e-06 pd=4.5e-06 m=1 region=sat
    \+799 (917 DR_S0 341 44) ami06N w=9e-07 l=6e-07 as=1.71e-12 ad=9.9e-13 \
        ps=4.5e-06 pd=2.1e-06 m=1 region=sat
    \+798 (918 DR_S0 343 44) ami06N w=9e-07 l=6e-07 as=1.71e-12 ad=9.9e-13 \
        ps=4.5e-06 pd=2.1e-06 m=1 region=sat
    \+797 (919 DR_S0B 343 44) ami06N w=9e-07 l=6e-07 as=1.71e-12 \
        ad=9.9e-13 ps=4.5e-06 pd=2.1e-06 m=1 region=sat
    \+796 (920 DR_S0 343 44) ami06N w=9e-07 l=6e-07 as=1.71e-12 ad=9.9e-13 \
        ps=4.5e-06 pd=2.1e-06 m=1 region=sat
    \+795 (921 DR_S0 345 44) ami06N w=9e-07 l=6e-07 as=1.71e-12 ad=9.9e-13 \
        ps=4.5e-06 pd=2.1e-06 m=1 region=sat
    \+794 (922 DR_S0B 345 44) ami06N w=9e-07 l=6e-07 as=1.71e-12 \
        ad=9.9e-13 ps=4.5e-06 pd=2.1e-06 m=1 region=sat
    \+793 (923 DR_S0 345 44) ami06N w=9e-07 l=6e-07 as=1.71e-12 ad=9.9e-13 \
        ps=4.5e-06 pd=2.1e-06 m=1 region=sat
    \+792 (924 DR_S0 347 44) ami06N w=9e-07 l=6e-07 as=1.71e-12 ad=9.9e-13 \
        ps=4.5e-06 pd=2.1e-06 m=1 region=sat
    \+791 (925 DR_S0B 347 44) ami06N w=9e-07 l=6e-07 as=1.71e-12 \
        ad=9.9e-13 ps=4.5e-06 pd=2.1e-06 m=1 region=sat
    \+790 (903 DR_S0 333 44) ami06N w=9e-07 l=6e-07 as=1.71e-12 ad=9.9e-13 \
        ps=4.5e-06 pd=2.1e-06 m=1 region=sat
    \+789 (926 DR_S0 347 44) ami06N w=9e-07 l=6e-07 as=1.71e-12 ad=9.9e-13 \
        ps=4.5e-06 pd=2.1e-06 m=1 region=sat
    \+788 (904 DR_S0B 333 44) ami06N w=9e-07 l=6e-07 as=1.71e-12 \
        ad=9.9e-13 ps=4.5e-06 pd=2.1e-06 m=1 region=sat
    \+787 (905 DR_S0 333 44) ami06N w=9e-07 l=6e-07 as=1.71e-12 ad=9.9e-13 \
        ps=4.5e-06 pd=2.1e-06 m=1 region=sat
    \+786 (906 DR_S0 335 44) ami06N w=9e-07 l=6e-07 as=1.71e-12 ad=9.9e-13 \
        ps=4.5e-06 pd=2.1e-06 m=1 region=sat
    \+785 (907 DR_S0B 335 44) ami06N w=9e-07 l=6e-07 as=1.71e-12 \
        ad=9.9e-13 ps=4.5e-06 pd=2.1e-06 m=1 region=sat
    \+784 (908 DR_S0 335 44) ami06N w=9e-07 l=6e-07 as=1.71e-12 ad=9.9e-13 \
        ps=4.5e-06 pd=2.1e-06 m=1 region=sat
    \+783 (909 DR_S0 337 44) ami06N w=9e-07 l=6e-07 as=1.71e-12 ad=9.9e-13 \
        ps=4.5e-06 pd=2.1e-06 m=1 region=sat
    \+782 (910 DR_S0B 337 44) ami06N w=9e-07 l=6e-07 as=1.71e-12 \
        ad=9.9e-13 ps=4.5e-06 pd=2.1e-06 m=1 region=sat
    \+781 (911 DR_S0 337 44) ami06N w=9e-07 l=6e-07 as=1.71e-12 ad=9.9e-13 \
        ps=4.5e-06 pd=2.1e-06 m=1 region=sat
    \+780 (912 DR_S0 339 44) ami06N w=9e-07 l=6e-07 as=1.71e-12 ad=9.9e-13 \
        ps=4.5e-06 pd=2.1e-06 m=1 region=sat
    \+779 (913 DR_S0B 339 44) ami06N w=9e-07 l=6e-07 as=1.71e-12 \
        ad=9.9e-13 ps=4.5e-06 pd=2.1e-06 m=1 region=sat
    \+778 (914 DR_S0 339 44) ami06N w=9e-07 l=6e-07 as=1.71e-12 ad=9.9e-13 \
        ps=4.5e-06 pd=2.1e-06 m=1 region=sat
    \+777 (915 DR_S0 341 44) ami06N w=9e-07 l=6e-07 as=1.71e-12 ad=9.9e-13 \
        ps=4.5e-06 pd=2.1e-06 m=1 region=sat
    \+776 (916 DR_S0B 341 44) ami06N w=9e-07 l=6e-07 as=1.71e-12 \
        ad=9.9e-13 ps=4.5e-06 pd=2.1e-06 m=1 region=sat
    \+775 (356 355 44 44) ami06N w=9e-07 l=6e-07 as=1.71e-12 ad=1.71e-12 \
        ps=4.5e-06 pd=4.5e-06 m=1 region=sat
    \+774 (357 244 44 44) ami06N w=9e-07 l=6e-07 as=1.71e-12 ad=1.71e-12 \
        ps=4.5e-06 pd=4.5e-06 m=1 region=sat
    \+773 (358 357 44 44) ami06N w=9e-07 l=6e-07 as=1.71e-12 ad=1.71e-12 \
        ps=4.5e-06 pd=4.5e-06 m=1 region=sat
    \+772 (359 245 44 44) ami06N w=9e-07 l=6e-07 as=1.71e-12 ad=1.71e-12 \
        ps=4.5e-06 pd=4.5e-06 m=1 region=sat
    \+771 (360 359 44 44) ami06N w=9e-07 l=6e-07 as=1.71e-12 ad=1.71e-12 \
        ps=4.5e-06 pd=4.5e-06 m=1 region=sat
    \+770 (361 246 44 44) ami06N w=9e-07 l=6e-07 as=1.71e-12 ad=1.71e-12 \
        ps=4.5e-06 pd=4.5e-06 m=1 region=sat
    \+769 (362 361 44 44) ami06N w=9e-07 l=6e-07 as=1.71e-12 ad=1.71e-12 \
        ps=4.5e-06 pd=4.5e-06 m=1 region=sat
    \+768 (363 247 44 44) ami06N w=9e-07 l=6e-07 as=1.71e-12 ad=1.71e-12 \
        ps=4.5e-06 pd=4.5e-06 m=1 region=sat
    \+767 (364 363 44 44) ami06N w=9e-07 l=6e-07 as=1.71e-12 ad=1.71e-12 \
        ps=4.5e-06 pd=4.5e-06 m=1 region=sat
    \+766 (349 240 44 44) ami06N w=9e-07 l=6e-07 as=1.71e-12 ad=1.71e-12 \
        ps=4.5e-06 pd=4.5e-06 m=1 region=sat
    \+765 (350 349 44 44) ami06N w=9e-07 l=6e-07 as=1.71e-12 ad=1.71e-12 \
        ps=4.5e-06 pd=4.5e-06 m=1 region=sat
    \+764 (351 241 44 44) ami06N w=9e-07 l=6e-07 as=1.71e-12 ad=1.71e-12 \
        ps=4.5e-06 pd=4.5e-06 m=1 region=sat
    \+763 (352 351 44 44) ami06N w=9e-07 l=6e-07 as=1.71e-12 ad=1.71e-12 \
        ps=4.5e-06 pd=4.5e-06 m=1 region=sat
    \+762 (353 242 44 44) ami06N w=9e-07 l=6e-07 as=1.71e-12 ad=1.71e-12 \
        ps=4.5e-06 pd=4.5e-06 m=1 region=sat
    \+761 (354 353 44 44) ami06N w=9e-07 l=6e-07 as=1.71e-12 ad=1.71e-12 \
        ps=4.5e-06 pd=4.5e-06 m=1 region=sat
    \+760 (355 243 44 44) ami06N w=9e-07 l=6e-07 as=1.71e-12 ad=1.71e-12 \
        ps=4.5e-06 pd=4.5e-06 m=1 region=sat
    \+740 (240 307 44 44) ami06N w=9e-07 l=6e-07 as=1.71e-12 ad=1.71e-12 \
        ps=4.5e-06 pd=4.5e-06 m=1 region=sat
    \+739 (241 308 44 44) ami06N w=9e-07 l=6e-07 as=1.71e-12 ad=1.71e-12 \
        ps=4.5e-06 pd=4.5e-06 m=1 region=sat
    \+738 (242 309 44 44) ami06N w=9e-07 l=6e-07 as=1.71e-12 ad=1.71e-12 \
        ps=4.5e-06 pd=4.5e-06 m=1 region=sat
    \+737 (243 310 44 44) ami06N w=9e-07 l=6e-07 as=1.71e-12 ad=1.71e-12 \
        ps=4.5e-06 pd=4.5e-06 m=1 region=sat
    \+736 (244 311 44 44) ami06N w=9e-07 l=6e-07 as=1.71e-12 ad=1.71e-12 \
        ps=4.5e-06 pd=4.5e-06 m=1 region=sat
    \+735 (245 312 44 44) ami06N w=9e-07 l=6e-07 as=1.71e-12 ad=1.71e-12 \
        ps=4.5e-06 pd=4.5e-06 m=1 region=sat
    \+734 (246 313 44 44) ami06N w=9e-07 l=6e-07 as=1.71e-12 ad=1.71e-12 \
        ps=4.5e-06 pd=4.5e-06 m=1 region=sat
    \+733 (247 314 44 44) ami06N w=9e-07 l=6e-07 as=1.71e-12 ad=1.71e-12 \
        ps=4.5e-06 pd=4.5e-06 m=1 region=sat
    \+732 (44 240 323 44) ami06N w=9e-07 l=6e-07 as=1.71e-12 ad=1.71e-12 \
        ps=4.5e-06 pd=4.5e-06 m=1 region=sat
    \+731 (44 241 324 44) ami06N w=9e-07 l=6e-07 as=1.71e-12 ad=1.71e-12 \
        ps=4.5e-06 pd=4.5e-06 m=1 region=sat
    \+730 (44 242 325 44) ami06N w=9e-07 l=6e-07 as=1.71e-12 ad=1.71e-12 \
        ps=4.5e-06 pd=4.5e-06 m=1 region=sat
    \+729 (44 243 326 44) ami06N w=9e-07 l=6e-07 as=1.71e-12 ad=1.71e-12 \
        ps=4.5e-06 pd=4.5e-06 m=1 region=sat
    \+728 (44 244 327 44) ami06N w=9e-07 l=6e-07 as=1.71e-12 ad=1.71e-12 \
        ps=4.5e-06 pd=4.5e-06 m=1 region=sat
    \+727 (44 245 328 44) ami06N w=9e-07 l=6e-07 as=1.71e-12 ad=1.71e-12 \
        ps=4.5e-06 pd=4.5e-06 m=1 region=sat
    \+726 (44 246 329 44) ami06N w=9e-07 l=6e-07 as=1.71e-12 ad=1.71e-12 \
        ps=4.5e-06 pd=4.5e-06 m=1 region=sat
    \+725 (44 247 330 44) ami06N w=9e-07 l=6e-07 as=1.71e-12 ad=1.71e-12 \
        ps=4.5e-06 pd=4.5e-06 m=1 region=sat
    \+724 (327 634 311 44) ami06N w=9e-07 l=6e-07 as=1.71e-12 ad=1.71e-12 \
        ps=4.5e-06 pd=4.5e-06 m=1 region=sat
    \+723 (328 634 312 44) ami06N w=9e-07 l=6e-07 as=1.71e-12 ad=1.71e-12 \
        ps=4.5e-06 pd=4.5e-06 m=1 region=sat
    \+722 (329 634 313 44) ami06N w=9e-07 l=6e-07 as=1.71e-12 ad=1.71e-12 \
        ps=4.5e-06 pd=4.5e-06 m=1 region=sat
    \+721 (330 634 314 44) ami06N w=9e-07 l=6e-07 as=1.71e-12 ad=1.71e-12 \
        ps=4.5e-06 pd=4.5e-06 m=1 region=sat
    \+720 (315 299 44 44) ami06N w=9e-07 l=6e-07 as=1.71e-12 ad=1.71e-12 \
        ps=4.5e-06 pd=4.5e-06 m=1 region=sat
    \+719 (316 300 44 44) ami06N w=9e-07 l=6e-07 as=1.71e-12 ad=1.71e-12 \
        ps=4.5e-06 pd=4.5e-06 m=1 region=sat
    \+718 (317 301 44 44) ami06N w=9e-07 l=6e-07 as=1.71e-12 ad=1.71e-12 \
        ps=4.5e-06 pd=4.5e-06 m=1 region=sat
    \+717 (318 302 44 44) ami06N w=9e-07 l=6e-07 as=1.71e-12 ad=1.71e-12 \
        ps=4.5e-06 pd=4.5e-06 m=1 region=sat
    \+716 (319 303 44 44) ami06N w=9e-07 l=6e-07 as=1.71e-12 ad=1.71e-12 \
        ps=4.5e-06 pd=4.5e-06 m=1 region=sat
    \+715 (320 304 44 44) ami06N w=9e-07 l=6e-07 as=1.71e-12 ad=1.71e-12 \
        ps=4.5e-06 pd=4.5e-06 m=1 region=sat
    \+714 (321 305 44 44) ami06N w=9e-07 l=6e-07 as=1.71e-12 ad=1.71e-12 \
        ps=4.5e-06 pd=4.5e-06 m=1 region=sat
    \+713 (322 306 44 44) ami06N w=9e-07 l=6e-07 as=1.71e-12 ad=1.71e-12 \
        ps=4.5e-06 pd=4.5e-06 m=1 region=sat
    \+712 (323 634 307 44) ami06N w=9e-07 l=6e-07 as=1.71e-12 ad=1.71e-12 \
        ps=4.5e-06 pd=4.5e-06 m=1 region=sat
    \+711 (324 634 308 44) ami06N w=9e-07 l=6e-07 as=1.71e-12 ad=1.71e-12 \
        ps=4.5e-06 pd=4.5e-06 m=1 region=sat
    \+710 (325 634 309 44) ami06N w=9e-07 l=6e-07 as=1.71e-12 ad=1.71e-12 \
        ps=4.5e-06 pd=4.5e-06 m=1 region=sat
    \+709 (326 634 310 44) ami06N w=9e-07 l=6e-07 as=1.71e-12 ad=1.71e-12 \
        ps=4.5e-06 pd=4.5e-06 m=1 region=sat
    \+708 (44 332 299 44) ami06N w=9e-07 l=6e-07 as=1.71e-12 ad=1.71e-12 \
        ps=4.5e-06 pd=4.5e-06 m=1 region=sat
    \+707 (44 334 300 44) ami06N w=9e-07 l=6e-07 as=1.71e-12 ad=1.71e-12 \
        ps=4.5e-06 pd=4.5e-06 m=1 region=sat
    \+706 (44 336 301 44) ami06N w=9e-07 l=6e-07 as=1.71e-12 ad=1.71e-12 \
        ps=4.5e-06 pd=4.5e-06 m=1 region=sat
    \+705 (44 338 302 44) ami06N w=9e-07 l=6e-07 as=1.71e-12 ad=1.71e-12 \
        ps=4.5e-06 pd=4.5e-06 m=1 region=sat
    \+704 (44 340 303 44) ami06N w=9e-07 l=6e-07 as=1.71e-12 ad=1.71e-12 \
        ps=4.5e-06 pd=4.5e-06 m=1 region=sat
    \+703 (44 342 304 44) ami06N w=9e-07 l=6e-07 as=1.71e-12 ad=1.71e-12 \
        ps=4.5e-06 pd=4.5e-06 m=1 region=sat
    \+702 (44 344 305 44) ami06N w=9e-07 l=6e-07 as=1.71e-12 ad=1.71e-12 \
        ps=4.5e-06 pd=4.5e-06 m=1 region=sat
    \+701 (44 346 306 44) ami06N w=9e-07 l=6e-07 as=1.71e-12 ad=1.71e-12 \
        ps=4.5e-06 pd=4.5e-06 m=1 region=sat
    \+700 (312 633 296 44) ami06N w=9e-07 l=6e-07 as=1.71e-12 ad=1.71e-12 \
        ps=4.5e-06 pd=4.5e-06 m=1 region=sat
    \+699 (313 633 297 44) ami06N w=9e-07 l=6e-07 as=1.71e-12 ad=1.71e-12 \
        ps=4.5e-06 pd=4.5e-06 m=1 region=sat
    \+698 (314 633 298 44) ami06N w=9e-07 l=6e-07 as=1.71e-12 ad=1.71e-12 \
        ps=4.5e-06 pd=4.5e-06 m=1 region=sat
    \+697 (307 633 291 44) ami06N w=9e-07 l=6e-07 as=1.71e-12 ad=1.71e-12 \
        ps=4.5e-06 pd=4.5e-06 m=1 region=sat
    \+696 (308 633 292 44) ami06N w=9e-07 l=6e-07 as=1.71e-12 ad=1.71e-12 \
        ps=4.5e-06 pd=4.5e-06 m=1 region=sat
    \+695 (309 633 293 44) ami06N w=9e-07 l=6e-07 as=1.71e-12 ad=1.71e-12 \
        ps=4.5e-06 pd=4.5e-06 m=1 region=sat
    \+694 (310 633 294 44) ami06N w=9e-07 l=6e-07 as=1.71e-12 ad=1.71e-12 \
        ps=4.5e-06 pd=4.5e-06 m=1 region=sat
    \+693 (311 633 295 44) ami06N w=9e-07 l=6e-07 as=1.71e-12 ad=1.71e-12 \
        ps=4.5e-06 pd=4.5e-06 m=1 region=sat
    \+692 (299 F2 283 44) ami06N w=9e-07 l=6e-07 as=1.71e-12 ad=1.71e-12 \
        ps=4.5e-06 pd=4.5e-06 m=1 region=sat
    \+691 (300 F2 284 44) ami06N w=9e-07 l=6e-07 as=1.71e-12 ad=1.71e-12 \
        ps=4.5e-06 pd=4.5e-06 m=1 region=sat
    \+690 (301 F2 285 44) ami06N w=9e-07 l=6e-07 as=1.71e-12 ad=1.71e-12 \
        ps=4.5e-06 pd=4.5e-06 m=1 region=sat
    \+689 (302 F2 286 44) ami06N w=9e-07 l=6e-07 as=1.71e-12 ad=1.71e-12 \
        ps=4.5e-06 pd=4.5e-06 m=1 region=sat
    \+688 (303 F2 287 44) ami06N w=9e-07 l=6e-07 as=1.71e-12 ad=1.71e-12 \
        ps=4.5e-06 pd=4.5e-06 m=1 region=sat
    \+687 (304 F2 288 44) ami06N w=9e-07 l=6e-07 as=1.71e-12 ad=1.71e-12 \
        ps=4.5e-06 pd=4.5e-06 m=1 region=sat
    \+686 (305 F2 289 44) ami06N w=9e-07 l=6e-07 as=1.71e-12 ad=1.71e-12 \
        ps=4.5e-06 pd=4.5e-06 m=1 region=sat
    \+685 (306 F2 290 44) ami06N w=9e-07 l=6e-07 as=1.71e-12 ad=1.71e-12 \
        ps=4.5e-06 pd=4.5e-06 m=1 region=sat
    \+684 (291 259 44 44) ami06N w=9e-07 l=6e-07 as=1.71e-12 ad=1.71e-12 \
        ps=4.5e-06 pd=4.5e-06 m=1 region=sat
    \+683 (292 261 44 44) ami06N w=9e-07 l=6e-07 as=1.71e-12 ad=1.71e-12 \
        ps=4.5e-06 pd=4.5e-06 m=1 region=sat
    \+682 (293 263 44 44) ami06N w=9e-07 l=6e-07 as=1.71e-12 ad=1.71e-12 \
        ps=4.5e-06 pd=4.5e-06 m=1 region=sat
    \+681 (294 265 44 44) ami06N w=9e-07 l=6e-07 as=1.71e-12 ad=1.71e-12 \
        ps=4.5e-06 pd=4.5e-06 m=1 region=sat
    \+680 (295 267 44 44) ami06N w=9e-07 l=6e-07 as=1.71e-12 ad=1.71e-12 \
        ps=4.5e-06 pd=4.5e-06 m=1 region=sat
    \+679 (296 269 44 44) ami06N w=9e-07 l=6e-07 as=1.71e-12 ad=1.71e-12 \
        ps=4.5e-06 pd=4.5e-06 m=1 region=sat
    \+678 (297 271 44 44) ami06N w=9e-07 l=6e-07 as=1.71e-12 ad=1.71e-12 \
        ps=4.5e-06 pd=4.5e-06 m=1 region=sat
    \+677 (298 273 44 44) ami06N w=9e-07 l=6e-07 as=1.71e-12 ad=1.71e-12 \
        ps=4.5e-06 pd=4.5e-06 m=1 region=sat
    \+676 (44 297 270 44) ami06N w=9e-07 l=6e-07 as=1.71e-12 ad=1.71e-12 \
        ps=4.5e-06 pd=4.5e-06 m=1 region=sat
    \+675 (44 298 272 44) ami06N w=9e-07 l=6e-07 as=1.71e-12 ad=1.71e-12 \
        ps=4.5e-06 pd=4.5e-06 m=1 region=sat
    \+674 (283 F1 274 44) ami06N w=9e-07 l=6e-07 as=1.71e-12 ad=1.71e-12 \
        ps=4.5e-06 pd=4.5e-06 m=1 region=sat
    \+673 (284 F1 275 44) ami06N w=9e-07 l=6e-07 as=1.71e-12 ad=1.71e-12 \
        ps=4.5e-06 pd=4.5e-06 m=1 region=sat
    \+672 (285 F1 276 44) ami06N w=9e-07 l=6e-07 as=1.71e-12 ad=1.71e-12 \
        ps=4.5e-06 pd=4.5e-06 m=1 region=sat
    \+671 (286 F1 277 44) ami06N w=9e-07 l=6e-07 as=1.71e-12 ad=1.71e-12 \
        ps=4.5e-06 pd=4.5e-06 m=1 region=sat
    \+670 (287 F1 278 44) ami06N w=9e-07 l=6e-07 as=1.71e-12 ad=1.71e-12 \
        ps=4.5e-06 pd=4.5e-06 m=1 region=sat
    \+669 (288 F1 279 44) ami06N w=9e-07 l=6e-07 as=1.71e-12 ad=1.71e-12 \
        ps=4.5e-06 pd=4.5e-06 m=1 region=sat
    \+668 (289 F1 280 44) ami06N w=9e-07 l=6e-07 as=1.71e-12 ad=1.71e-12 \
        ps=4.5e-06 pd=4.5e-06 m=1 region=sat
    \+667 (290 F1 281 44) ami06N w=9e-07 l=6e-07 as=1.71e-12 ad=1.71e-12 \
        ps=4.5e-06 pd=4.5e-06 m=1 region=sat
    \+666 (44 291 258 44) ami06N w=9e-07 l=6e-07 as=1.71e-12 ad=1.71e-12 \
        ps=4.5e-06 pd=4.5e-06 m=1 region=sat
    \+665 (44 292 260 44) ami06N w=9e-07 l=6e-07 as=1.71e-12 ad=1.71e-12 \
        ps=4.5e-06 pd=4.5e-06 m=1 region=sat
    \+664 (44 293 262 44) ami06N w=9e-07 l=6e-07 as=1.71e-12 ad=1.71e-12 \
        ps=4.5e-06 pd=4.5e-06 m=1 region=sat
    \+663 (44 294 264 44) ami06N w=9e-07 l=6e-07 as=1.71e-12 ad=1.71e-12 \
        ps=4.5e-06 pd=4.5e-06 m=1 region=sat
    \+662 (44 295 266 44) ami06N w=9e-07 l=6e-07 as=1.71e-12 ad=1.71e-12 \
        ps=4.5e-06 pd=4.5e-06 m=1 region=sat
    \+661 (44 296 268 44) ami06N w=9e-07 l=6e-07 as=1.71e-12 ad=1.71e-12 \
        ps=4.5e-06 pd=4.5e-06 m=1 region=sat
    \+659 (274 221 44 44) ami06N w=9e-07 l=6e-07 as=1.71e-12 ad=1.71e-12 \
        ps=4.5e-06 pd=4.5e-06 m=1 region=sat
    \+658 (275 222 44 44) ami06N w=9e-07 l=6e-07 as=1.71e-12 ad=1.71e-12 \
        ps=4.5e-06 pd=4.5e-06 m=1 region=sat
    \+657 (276 223 44 44) ami06N w=9e-07 l=6e-07 as=1.71e-12 ad=1.71e-12 \
        ps=4.5e-06 pd=4.5e-06 m=1 region=sat
    \+656 (277 224 44 44) ami06N w=9e-07 l=6e-07 as=1.71e-12 ad=1.71e-12 \
        ps=4.5e-06 pd=4.5e-06 m=1 region=sat
    \+655 (278 225 44 44) ami06N w=9e-07 l=6e-07 as=1.71e-12 ad=1.71e-12 \
        ps=4.5e-06 pd=4.5e-06 m=1 region=sat
    \+654 (279 226 44 44) ami06N w=9e-07 l=6e-07 as=1.71e-12 ad=1.71e-12 \
        ps=4.5e-06 pd=4.5e-06 m=1 region=sat
    \+653 (280 227 44 44) ami06N w=9e-07 l=6e-07 as=1.71e-12 ad=1.71e-12 \
        ps=4.5e-06 pd=4.5e-06 m=1 region=sat
    \+652 (281 228 44 44) ami06N w=9e-07 l=6e-07 as=1.71e-12 ad=1.71e-12 \
        ps=4.5e-06 pd=4.5e-06 m=1 region=sat
    \+651 (44 283 221 44) ami06N w=9e-07 l=6e-07 as=1.71e-12 ad=1.71e-12 \
        ps=4.5e-06 pd=4.5e-06 m=1 region=sat
    \+650 (44 284 222 44) ami06N w=9e-07 l=6e-07 as=1.71e-12 ad=1.71e-12 \
        ps=4.5e-06 pd=4.5e-06 m=1 region=sat
    \+649 (44 285 223 44) ami06N w=9e-07 l=6e-07 as=1.71e-12 ad=1.71e-12 \
        ps=4.5e-06 pd=4.5e-06 m=1 region=sat
    \+648 (44 286 224 44) ami06N w=9e-07 l=6e-07 as=1.71e-12 ad=1.71e-12 \
        ps=4.5e-06 pd=4.5e-06 m=1 region=sat
    \+647 (44 287 225 44) ami06N w=9e-07 l=6e-07 as=1.71e-12 ad=1.71e-12 \
        ps=4.5e-06 pd=4.5e-06 m=1 region=sat
    \+646 (44 288 226 44) ami06N w=9e-07 l=6e-07 as=1.71e-12 ad=1.71e-12 \
        ps=4.5e-06 pd=4.5e-06 m=1 region=sat
    \+645 (44 289 227 44) ami06N w=9e-07 l=6e-07 as=1.71e-12 ad=1.71e-12 \
        ps=4.5e-06 pd=4.5e-06 m=1 region=sat
    \+644 (44 290 228 44) ami06N w=9e-07 l=6e-07 as=1.71e-12 ad=1.71e-12 \
        ps=4.5e-06 pd=4.5e-06 m=1 region=sat
    \+625 (253 631 883 44) ami06N w=9e-07 l=6e-07 as=1.755e-12 ad=1.71e-12 \
        ps=3.9e-06 pd=4.5e-06 m=1 region=sat
    \+624 (253 632 884 44) ami06N w=9e-07 l=6e-07 as=1.755e-12 ad=1.71e-12 \
        ps=3.9e-06 pd=4.5e-06 m=1 region=sat
    \+623 (253 631 885 44) ami06N w=9e-07 l=6e-07 as=1.755e-12 ad=1.71e-12 \
        ps=3.9e-06 pd=4.5e-06 m=1 region=sat
    \+622 (249 631 863 44) ami06N w=9e-07 l=6e-07 as=1.755e-12 ad=1.71e-12 \
        ps=3.9e-06 pd=4.5e-06 m=1 region=sat
    \+621 (253 632 886 44) ami06N w=9e-07 l=6e-07 as=1.755e-12 ad=1.71e-12 \
        ps=3.9e-06 pd=4.5e-06 m=1 region=sat
    \+620 (249 632 864 44) ami06N w=9e-07 l=6e-07 as=1.755e-12 ad=1.71e-12 \
        ps=3.9e-06 pd=4.5e-06 m=1 region=sat
    \+619 (253 631 887 44) ami06N w=9e-07 l=6e-07 as=1.755e-12 ad=1.71e-12 \
        ps=3.9e-06 pd=4.5e-06 m=1 region=sat
    \+618 (249 631 865 44) ami06N w=9e-07 l=6e-07 as=1.755e-12 ad=1.71e-12 \
        ps=3.9e-06 pd=4.5e-06 m=1 region=sat
    \+617 (254 631 888 44) ami06N w=9e-07 l=6e-07 as=1.755e-12 ad=1.71e-12 \
        ps=3.9e-06 pd=4.5e-06 m=1 region=sat
    \+616 (249 632 866 44) ami06N w=9e-07 l=6e-07 as=1.755e-12 ad=1.71e-12 \
        ps=3.9e-06 pd=4.5e-06 m=1 region=sat
    \+615 (254 632 889 44) ami06N w=9e-07 l=6e-07 as=1.755e-12 ad=1.71e-12 \
        ps=3.9e-06 pd=4.5e-06 m=1 region=sat
    \+614 (249 631 867 44) ami06N w=9e-07 l=6e-07 as=1.755e-12 ad=1.71e-12 \
        ps=3.9e-06 pd=4.5e-06 m=1 region=sat
    \+613 (254 631 890 44) ami06N w=9e-07 l=6e-07 as=1.755e-12 ad=1.71e-12 \
        ps=3.9e-06 pd=4.5e-06 m=1 region=sat
    \+612 (250 631 868 44) ami06N w=9e-07 l=6e-07 as=1.755e-12 ad=1.71e-12 \
        ps=3.9e-06 pd=4.5e-06 m=1 region=sat
    \+611 (254 632 891 44) ami06N w=9e-07 l=6e-07 as=1.755e-12 ad=1.71e-12 \
        ps=3.9e-06 pd=4.5e-06 m=1 region=sat
    \+610 (250 632 869 44) ami06N w=9e-07 l=6e-07 as=1.755e-12 ad=1.71e-12 \
        ps=3.9e-06 pd=4.5e-06 m=1 region=sat
    \+609 (254 631 892 44) ami06N w=9e-07 l=6e-07 as=1.755e-12 ad=1.71e-12 \
        ps=3.9e-06 pd=4.5e-06 m=1 region=sat
    \+608 (250 631 870 44) ami06N w=9e-07 l=6e-07 as=1.755e-12 ad=1.71e-12 \
        ps=3.9e-06 pd=4.5e-06 m=1 region=sat
    \+607 (255 631 893 44) ami06N w=9e-07 l=6e-07 as=1.755e-12 ad=1.71e-12 \
        ps=3.9e-06 pd=4.5e-06 m=1 region=sat
    \+606 (250 632 871 44) ami06N w=9e-07 l=6e-07 as=1.755e-12 ad=1.71e-12 \
        ps=3.9e-06 pd=4.5e-06 m=1 region=sat
    \+605 (255 632 894 44) ami06N w=9e-07 l=6e-07 as=1.755e-12 ad=1.71e-12 \
        ps=3.9e-06 pd=4.5e-06 m=1 region=sat
    \+604 (250 631 872 44) ami06N w=9e-07 l=6e-07 as=1.755e-12 ad=1.71e-12 \
        ps=3.9e-06 pd=4.5e-06 m=1 region=sat
    \+603 (255 631 895 44) ami06N w=9e-07 l=6e-07 as=1.755e-12 ad=1.71e-12 \
        ps=3.9e-06 pd=4.5e-06 m=1 region=sat
    \+602 (251 631 873 44) ami06N w=9e-07 l=6e-07 as=1.755e-12 ad=1.71e-12 \
        ps=3.9e-06 pd=4.5e-06 m=1 region=sat
    \+601 (255 632 896 44) ami06N w=9e-07 l=6e-07 as=1.755e-12 ad=1.71e-12 \
        ps=3.9e-06 pd=4.5e-06 m=1 region=sat
    \+600 (251 632 874 44) ami06N w=9e-07 l=6e-07 as=1.755e-12 ad=1.71e-12 \
        ps=3.9e-06 pd=4.5e-06 m=1 region=sat
    \+599 (255 631 897 44) ami06N w=9e-07 l=6e-07 as=1.755e-12 ad=1.71e-12 \
        ps=3.9e-06 pd=4.5e-06 m=1 region=sat
    \+598 (251 631 875 44) ami06N w=9e-07 l=6e-07 as=1.755e-12 ad=1.71e-12 \
        ps=3.9e-06 pd=4.5e-06 m=1 region=sat
    \+597 (256 631 898 44) ami06N w=9e-07 l=6e-07 as=1.755e-12 ad=1.71e-12 \
        ps=3.9e-06 pd=4.5e-06 m=1 region=sat
    \+596 (251 632 876 44) ami06N w=9e-07 l=6e-07 as=1.755e-12 ad=1.71e-12 \
        ps=3.9e-06 pd=4.5e-06 m=1 region=sat
    \+595 (256 632 899 44) ami06N w=9e-07 l=6e-07 as=1.755e-12 ad=1.71e-12 \
        ps=3.9e-06 pd=4.5e-06 m=1 region=sat
    \+594 (251 631 877 44) ami06N w=9e-07 l=6e-07 as=1.755e-12 ad=1.71e-12 \
        ps=3.9e-06 pd=4.5e-06 m=1 region=sat
    \+593 (256 631 900 44) ami06N w=9e-07 l=6e-07 as=1.755e-12 ad=1.71e-12 \
        ps=3.9e-06 pd=4.5e-06 m=1 region=sat
    \+592 (252 631 878 44) ami06N w=9e-07 l=6e-07 as=1.755e-12 ad=1.71e-12 \
        ps=3.9e-06 pd=4.5e-06 m=1 region=sat
    \+591 (256 632 901 44) ami06N w=9e-07 l=6e-07 as=1.755e-12 ad=1.71e-12 \
        ps=3.9e-06 pd=4.5e-06 m=1 region=sat
    \+590 (252 632 879 44) ami06N w=9e-07 l=6e-07 as=1.755e-12 ad=1.71e-12 \
        ps=3.9e-06 pd=4.5e-06 m=1 region=sat
    \+589 (256 631 902 44) ami06N w=9e-07 l=6e-07 as=1.755e-12 ad=1.71e-12 \
        ps=3.9e-06 pd=4.5e-06 m=1 region=sat
    \+588 (252 631 880 44) ami06N w=9e-07 l=6e-07 as=1.755e-12 ad=1.71e-12 \
        ps=3.9e-06 pd=4.5e-06 m=1 region=sat
    \+587 (252 632 881 44) ami06N w=9e-07 l=6e-07 as=1.755e-12 ad=1.71e-12 \
        ps=3.9e-06 pd=4.5e-06 m=1 region=sat
    \+586 (252 631 882 44) ami06N w=9e-07 l=6e-07 as=1.755e-12 ad=1.71e-12 \
        ps=3.9e-06 pd=4.5e-06 m=1 region=sat
    \+584 (878 629 838 44) ami06N w=9e-07 l=6e-07 as=9.9e-13 ad=1.755e-12 \
        ps=2.1e-06 pd=3.9e-06 m=1 region=sat
    \+583 (901 630 861 44) ami06N w=9e-07 l=6e-07 as=9.9e-13 ad=1.755e-12 \
        ps=2.1e-06 pd=3.9e-06 m=1 region=sat
    \+582 (879 629 839 44) ami06N w=9e-07 l=6e-07 as=9.9e-13 ad=1.755e-12 \
        ps=2.1e-06 pd=3.9e-06 m=1 region=sat
    \+581 (902 629 862 44) ami06N w=9e-07 l=6e-07 as=9.9e-13 ad=1.755e-12 \
        ps=2.1e-06 pd=3.9e-06 m=1 region=sat
    \+580 (880 630 840 44) ami06N w=9e-07 l=6e-07 as=9.9e-13 ad=1.755e-12 \
        ps=2.1e-06 pd=3.9e-06 m=1 region=sat
    \+579 (881 630 841 44) ami06N w=9e-07 l=6e-07 as=9.9e-13 ad=1.755e-12 \
        ps=2.1e-06 pd=3.9e-06 m=1 region=sat
    \+578 (882 629 842 44) ami06N w=9e-07 l=6e-07 as=9.9e-13 ad=1.755e-12 \
        ps=2.1e-06 pd=3.9e-06 m=1 region=sat
    \+577 (883 629 843 44) ami06N w=9e-07 l=6e-07 as=9.9e-13 ad=1.755e-12 \
        ps=2.1e-06 pd=3.9e-06 m=1 region=sat
    \+576 (884 629 844 44) ami06N w=9e-07 l=6e-07 as=9.9e-13 ad=1.755e-12 \
        ps=2.1e-06 pd=3.9e-06 m=1 region=sat
    \+575 (885 630 845 44) ami06N w=9e-07 l=6e-07 as=9.9e-13 ad=1.755e-12 \
        ps=2.1e-06 pd=3.9e-06 m=1 region=sat
    \+574 (863 629 823 44) ami06N w=9e-07 l=6e-07 as=9.9e-13 ad=1.755e-12 \
        ps=2.1e-06 pd=3.9e-06 m=1 region=sat
    \+573 (886 630 846 44) ami06N w=9e-07 l=6e-07 as=9.9e-13 ad=1.755e-12 \
        ps=2.1e-06 pd=3.9e-06 m=1 region=sat
    \+572 (864 629 824 44) ami06N w=9e-07 l=6e-07 as=9.9e-13 ad=1.755e-12 \
        ps=2.1e-06 pd=3.9e-06 m=1 region=sat
    \+571 (887 629 847 44) ami06N w=9e-07 l=6e-07 as=9.9e-13 ad=1.755e-12 \
        ps=2.1e-06 pd=3.9e-06 m=1 region=sat
    \+570 (865 630 825 44) ami06N w=9e-07 l=6e-07 as=9.9e-13 ad=1.755e-12 \
        ps=2.1e-06 pd=3.9e-06 m=1 region=sat
    \+569 (888 629 848 44) ami06N w=9e-07 l=6e-07 as=9.9e-13 ad=1.755e-12 \
        ps=2.1e-06 pd=3.9e-06 m=1 region=sat
    \+568 (866 630 826 44) ami06N w=9e-07 l=6e-07 as=9.9e-13 ad=1.755e-12 \
        ps=2.1e-06 pd=3.9e-06 m=1 region=sat
    \+567 (889 629 849 44) ami06N w=9e-07 l=6e-07 as=9.9e-13 ad=1.755e-12 \
        ps=2.1e-06 pd=3.9e-06 m=1 region=sat
    \+566 (867 629 827 44) ami06N w=9e-07 l=6e-07 as=9.9e-13 ad=1.755e-12 \
        ps=2.1e-06 pd=3.9e-06 m=1 region=sat
    \+565 (890 630 850 44) ami06N w=9e-07 l=6e-07 as=9.9e-13 ad=1.755e-12 \
        ps=2.1e-06 pd=3.9e-06 m=1 region=sat
    \+564 (868 629 828 44) ami06N w=9e-07 l=6e-07 as=9.9e-13 ad=1.755e-12 \
        ps=2.1e-06 pd=3.9e-06 m=1 region=sat
    \+563 (891 630 851 44) ami06N w=9e-07 l=6e-07 as=9.9e-13 ad=1.755e-12 \
        ps=2.1e-06 pd=3.9e-06 m=1 region=sat
    \+562 (869 629 829 44) ami06N w=9e-07 l=6e-07 as=9.9e-13 ad=1.755e-12 \
        ps=2.1e-06 pd=3.9e-06 m=1 region=sat
    \+561 (892 629 852 44) ami06N w=9e-07 l=6e-07 as=9.9e-13 ad=1.755e-12 \
        ps=2.1e-06 pd=3.9e-06 m=1 region=sat
    \+560 (870 630 830 44) ami06N w=9e-07 l=6e-07 as=9.9e-13 ad=1.755e-12 \
        ps=2.1e-06 pd=3.9e-06 m=1 region=sat
    \+559 (893 629 853 44) ami06N w=9e-07 l=6e-07 as=9.9e-13 ad=1.755e-12 \
        ps=2.1e-06 pd=3.9e-06 m=1 region=sat
    \+558 (871 630 831 44) ami06N w=9e-07 l=6e-07 as=9.9e-13 ad=1.755e-12 \
        ps=2.1e-06 pd=3.9e-06 m=1 region=sat
    \+557 (894 629 854 44) ami06N w=9e-07 l=6e-07 as=9.9e-13 ad=1.755e-12 \
        ps=2.1e-06 pd=3.9e-06 m=1 region=sat
    \+556 (872 629 832 44) ami06N w=9e-07 l=6e-07 as=9.9e-13 ad=1.755e-12 \
        ps=2.1e-06 pd=3.9e-06 m=1 region=sat
    \+555 (895 630 855 44) ami06N w=9e-07 l=6e-07 as=9.9e-13 ad=1.755e-12 \
        ps=2.1e-06 pd=3.9e-06 m=1 region=sat
    \+554 (873 629 833 44) ami06N w=9e-07 l=6e-07 as=9.9e-13 ad=1.755e-12 \
        ps=2.1e-06 pd=3.9e-06 m=1 region=sat
    \+553 (896 630 856 44) ami06N w=9e-07 l=6e-07 as=9.9e-13 ad=1.755e-12 \
        ps=2.1e-06 pd=3.9e-06 m=1 region=sat
    \+552 (874 629 834 44) ami06N w=9e-07 l=6e-07 as=9.9e-13 ad=1.755e-12 \
        ps=2.1e-06 pd=3.9e-06 m=1 region=sat
    \+551 (897 629 857 44) ami06N w=9e-07 l=6e-07 as=9.9e-13 ad=1.755e-12 \
        ps=2.1e-06 pd=3.9e-06 m=1 region=sat
    \+550 (875 630 835 44) ami06N w=9e-07 l=6e-07 as=9.9e-13 ad=1.755e-12 \
        ps=2.1e-06 pd=3.9e-06 m=1 region=sat
    \+549 (898 629 858 44) ami06N w=9e-07 l=6e-07 as=9.9e-13 ad=1.755e-12 \
        ps=2.1e-06 pd=3.9e-06 m=1 region=sat
    \+548 (876 630 836 44) ami06N w=9e-07 l=6e-07 as=9.9e-13 ad=1.755e-12 \
        ps=2.1e-06 pd=3.9e-06 m=1 region=sat
    \+547 (899 629 859 44) ami06N w=9e-07 l=6e-07 as=9.9e-13 ad=1.755e-12 \
        ps=2.1e-06 pd=3.9e-06 m=1 region=sat
    \+546 (877 629 837 44) ami06N w=9e-07 l=6e-07 as=9.9e-13 ad=1.755e-12 \
        ps=2.1e-06 pd=3.9e-06 m=1 region=sat
    \+545 (900 630 860 44) ami06N w=9e-07 l=6e-07 as=9.9e-13 ad=1.755e-12 \
        ps=2.1e-06 pd=3.9e-06 m=1 region=sat
    \+544 (832 628 242 44) ami06N w=9e-07 l=6e-07 as=1.71e-12 ad=9.9e-13 \
        ps=4.5e-06 pd=2.1e-06 m=1 region=sat
    \+543 (855 627 44 44) ami06N w=9e-07 l=6e-07 as=1.71e-12 ad=9.9e-13 \
        ps=4.5e-06 pd=2.1e-06 m=1 region=sat
    \+542 (833 627 242 44) ami06N w=9e-07 l=6e-07 as=1.71e-12 ad=9.9e-13 \
        ps=4.5e-06 pd=2.1e-06 m=1 region=sat
    \+541 (856 627 245 44) ami06N w=9e-07 l=6e-07 as=1.71e-12 ad=9.9e-13 \
        ps=4.5e-06 pd=2.1e-06 m=1 region=sat
    \+540 (834 627 232 44) ami06N w=9e-07 l=6e-07 as=1.71e-12 ad=9.9e-13 \
        ps=4.5e-06 pd=2.1e-06 m=1 region=sat
    \+539 (857 628 247 44) ami06N w=9e-07 l=6e-07 as=1.71e-12 ad=9.9e-13 \
        ps=4.5e-06 pd=2.1e-06 m=1 region=sat
    \+538 (835 627 44 44) ami06N w=9e-07 l=6e-07 as=1.71e-12 ad=9.9e-13 \
        ps=4.5e-06 pd=2.1e-06 m=1 region=sat
    \+537 (858 627 247 44) ami06N w=9e-07 l=6e-07 as=1.71e-12 ad=9.9e-13 \
        ps=4.5e-06 pd=2.1e-06 m=1 region=sat
    \+536 (836 627 241 44) ami06N w=9e-07 l=6e-07 as=1.71e-12 ad=9.9e-13 \
        ps=4.5e-06 pd=2.1e-06 m=1 region=sat
    \+535 (859 627 237 44) ami06N w=9e-07 l=6e-07 as=1.71e-12 ad=9.9e-13 \
        ps=4.5e-06 pd=2.1e-06 m=1 region=sat
    \+534 (837 628 243 44) ami06N w=9e-07 l=6e-07 as=1.71e-12 ad=9.9e-13 \
        ps=4.5e-06 pd=2.1e-06 m=1 region=sat
    \+533 (860 627 44 44) ami06N w=9e-07 l=6e-07 as=1.71e-12 ad=9.9e-13 \
        ps=4.5e-06 pd=2.1e-06 m=1 region=sat
    \+532 (838 627 243 44) ami06N w=9e-07 l=6e-07 as=1.71e-12 ad=9.9e-13 \
        ps=4.5e-06 pd=2.1e-06 m=1 region=sat
    \+531 (861 627 246 44) ami06N w=9e-07 l=6e-07 as=1.71e-12 ad=9.9e-13 \
        ps=4.5e-06 pd=2.1e-06 m=1 region=sat
    \+530 (839 627 233 44) ami06N w=9e-07 l=6e-07 as=1.71e-12 ad=9.9e-13 \
        ps=4.5e-06 pd=2.1e-06 m=1 region=sat
    \+529 (862 628 44 44) ami06N w=9e-07 l=6e-07 as=1.71e-12 ad=9.9e-13 \
        ps=4.5e-06 pd=2.1e-06 m=1 region=sat
    \+528 (840 627 44 44) ami06N w=9e-07 l=6e-07 as=1.71e-12 ad=9.9e-13 \
        ps=4.5e-06 pd=2.1e-06 m=1 region=sat
    \+527 (841 627 242 44) ami06N w=9e-07 l=6e-07 as=1.71e-12 ad=9.9e-13 \
        ps=4.5e-06 pd=2.1e-06 m=1 region=sat
    \+526 (842 628 244 44) ami06N w=9e-07 l=6e-07 as=1.71e-12 ad=9.9e-13 \
        ps=4.5e-06 pd=2.1e-06 m=1 region=sat
    \+525 (843 627 244 44) ami06N w=9e-07 l=6e-07 as=1.71e-12 ad=9.9e-13 \
        ps=4.5e-06 pd=2.1e-06 m=1 region=sat
    \+524 (844 627 234 44) ami06N w=9e-07 l=6e-07 as=1.71e-12 ad=9.9e-13 \
        ps=4.5e-06 pd=2.1e-06 m=1 region=sat
    \+523 (845 627 44 44) ami06N w=9e-07 l=6e-07 as=1.71e-12 ad=9.9e-13 \
        ps=4.5e-06 pd=2.1e-06 m=1 region=sat
    \+522 (823 627 240 44) ami06N w=9e-07 l=6e-07 as=1.71e-12 ad=9.9e-13 \
        ps=4.5e-06 pd=2.1e-06 m=1 region=sat
    \+521 (846 627 243 44) ami06N w=9e-07 l=6e-07 as=1.71e-12 ad=9.9e-13 \
        ps=4.5e-06 pd=2.1e-06 m=1 region=sat
    \+520 (824 627 230 44) ami06N w=9e-07 l=6e-07 as=1.71e-12 ad=9.9e-13 \
        ps=4.5e-06 pd=2.1e-06 m=1 region=sat
    \+519 (847 628 245 44) ami06N w=9e-07 l=6e-07 as=1.71e-12 ad=9.9e-13 \
        ps=4.5e-06 pd=2.1e-06 m=1 region=sat
    \+518 (825 627 44 44) ami06N w=9e-07 l=6e-07 as=1.71e-12 ad=9.9e-13 \
        ps=4.5e-06 pd=2.1e-06 m=1 region=sat
    \+517 (848 627 245 44) ami06N w=9e-07 l=6e-07 as=1.71e-12 ad=9.9e-13 \
        ps=4.5e-06 pd=2.1e-06 m=1 region=sat
    \+516 (826 627 44 44) ami06N w=9e-07 l=6e-07 as=1.71e-12 ad=9.9e-13 \
        ps=4.5e-06 pd=2.1e-06 m=1 region=sat
    \+515 (849 627 235 44) ami06N w=9e-07 l=6e-07 as=1.71e-12 ad=9.9e-13 \
        ps=4.5e-06 pd=2.1e-06 m=1 region=sat
    \+514 (827 628 241 44) ami06N w=9e-07 l=6e-07 as=1.71e-12 ad=9.9e-13 \
        ps=4.5e-06 pd=2.1e-06 m=1 region=sat
    \+513 (850 627 44 44) ami06N w=9e-07 l=6e-07 as=1.71e-12 ad=9.9e-13 \
        ps=4.5e-06 pd=2.1e-06 m=1 region=sat
    \+512 (828 627 241 44) ami06N w=9e-07 l=6e-07 as=1.71e-12 ad=9.9e-13 \
        ps=4.5e-06 pd=2.1e-06 m=1 region=sat
    \+511 (851 627 244 44) ami06N w=9e-07 l=6e-07 as=1.71e-12 ad=9.9e-13 \
        ps=4.5e-06 pd=2.1e-06 m=1 region=sat
    \+510 (829 627 231 44) ami06N w=9e-07 l=6e-07 as=1.71e-12 ad=9.9e-13 \
        ps=4.5e-06 pd=2.1e-06 m=1 region=sat
    \+509 (852 628 246 44) ami06N w=9e-07 l=6e-07 as=1.71e-12 ad=9.9e-13 \
        ps=4.5e-06 pd=2.1e-06 m=1 region=sat
    \+508 (830 627 44 44) ami06N w=9e-07 l=6e-07 as=1.71e-12 ad=9.9e-13 \
        ps=4.5e-06 pd=2.1e-06 m=1 region=sat
    \+507 (853 627 246 44) ami06N w=9e-07 l=6e-07 as=1.71e-12 ad=9.9e-13 \
        ps=4.5e-06 pd=2.1e-06 m=1 region=sat
    \+506 (831 627 240 44) ami06N w=9e-07 l=6e-07 as=1.71e-12 ad=9.9e-13 \
        ps=4.5e-06 pd=2.1e-06 m=1 region=sat
    \+505 (854 627 236 44) ami06N w=9e-07 l=6e-07 as=1.71e-12 ad=9.9e-13 \
        ps=4.5e-06 pd=2.1e-06 m=1 region=sat
    \+501 (233 625 789 44) ami06N w=9e-07 l=6e-07 as=1.755e-12 ad=1.71e-12 \
        ps=3.9e-06 pd=4.5e-06 m=1 region=sat
    \+500 (236 625 812 44) ami06N w=9e-07 l=6e-07 as=1.755e-12 ad=1.71e-12 \
        ps=3.9e-06 pd=4.5e-06 m=1 region=sat
    \+499 (230 625 767 44) ami06N w=9e-07 l=6e-07 as=1.755e-12 ad=1.71e-12 \
        ps=3.9e-06 pd=4.5e-06 m=1 region=sat
    \+498 (233 626 790 44) ami06N w=9e-07 l=6e-07 as=1.755e-12 ad=1.71e-12 \
        ps=3.9e-06 pd=4.5e-06 m=1 region=sat
    \+497 (236 626 813 44) ami06N w=9e-07 l=6e-07 as=1.755e-12 ad=1.71e-12 \
        ps=3.9e-06 pd=4.5e-06 m=1 region=sat
    \+496 (230 625 768 44) ami06N w=9e-07 l=6e-07 as=1.755e-12 ad=1.71e-12 \
        ps=3.9e-06 pd=4.5e-06 m=1 region=sat
    \+495 (233 625 791 44) ami06N w=9e-07 l=6e-07 as=1.755e-12 ad=1.71e-12 \
        ps=3.9e-06 pd=4.5e-06 m=1 region=sat
    \+494 (236 625 814 44) ami06N w=9e-07 l=6e-07 as=1.755e-12 ad=1.71e-12 \
        ps=3.9e-06 pd=4.5e-06 m=1 region=sat
    \+493 (230 626 769 44) ami06N w=9e-07 l=6e-07 as=1.755e-12 ad=1.71e-12 \
        ps=3.9e-06 pd=4.5e-06 m=1 region=sat
    \+492 (233 626 792 44) ami06N w=9e-07 l=6e-07 as=1.755e-12 ad=1.71e-12 \
        ps=3.9e-06 pd=4.5e-06 m=1 region=sat
    \+491 (236 626 815 44) ami06N w=9e-07 l=6e-07 as=1.755e-12 ad=1.71e-12 \
        ps=3.9e-06 pd=4.5e-06 m=1 region=sat
    \+490 (230 625 770 44) ami06N w=9e-07 l=6e-07 as=1.755e-12 ad=1.71e-12 \
        ps=3.9e-06 pd=4.5e-06 m=1 region=sat
    \+489 (233 625 793 44) ami06N w=9e-07 l=6e-07 as=1.755e-12 ad=1.71e-12 \
        ps=3.9e-06 pd=4.5e-06 m=1 region=sat
    \+488 (237 625 816 44) ami06N w=9e-07 l=6e-07 as=1.755e-12 ad=1.71e-12 \
        ps=3.9e-06 pd=4.5e-06 m=1 region=sat
    \+487 (230 626 771 44) ami06N w=9e-07 l=6e-07 as=1.755e-12 ad=1.71e-12 \
        ps=3.9e-06 pd=4.5e-06 m=1 region=sat
    \+486 (233 626 794 44) ami06N w=9e-07 l=6e-07 as=1.755e-12 ad=1.71e-12 \
        ps=3.9e-06 pd=4.5e-06 m=1 region=sat
    \+485 (237 625 817 44) ami06N w=9e-07 l=6e-07 as=1.755e-12 ad=1.71e-12 \
        ps=3.9e-06 pd=4.5e-06 m=1 region=sat
    \+484 (230 625 772 44) ami06N w=9e-07 l=6e-07 as=1.755e-12 ad=1.71e-12 \
        ps=3.9e-06 pd=4.5e-06 m=1 region=sat
    \+483 (234 625 795 44) ami06N w=9e-07 l=6e-07 as=1.755e-12 ad=1.71e-12 \
        ps=3.9e-06 pd=4.5e-06 m=1 region=sat
    \+482 (237 626 818 44) ami06N w=9e-07 l=6e-07 as=1.755e-12 ad=1.71e-12 \
        ps=3.9e-06 pd=4.5e-06 m=1 region=sat
    \+481 (230 626 773 44) ami06N w=9e-07 l=6e-07 as=1.755e-12 ad=1.71e-12 \
        ps=3.9e-06 pd=4.5e-06 m=1 region=sat
    \+480 (234 625 796 44) ami06N w=9e-07 l=6e-07 as=1.755e-12 ad=1.71e-12 \
        ps=3.9e-06 pd=4.5e-06 m=1 region=sat
    \+479 (237 625 819 44) ami06N w=9e-07 l=6e-07 as=1.755e-12 ad=1.71e-12 \
        ps=3.9e-06 pd=4.5e-06 m=1 region=sat
    \+478 (231 625 774 44) ami06N w=9e-07 l=6e-07 as=1.755e-12 ad=1.71e-12 \
        ps=3.9e-06 pd=4.5e-06 m=1 region=sat
    \+477 (234 626 797 44) ami06N w=9e-07 l=6e-07 as=1.755e-12 ad=1.71e-12 \
        ps=3.9e-06 pd=4.5e-06 m=1 region=sat
    \+476 (237 626 820 44) ami06N w=9e-07 l=6e-07 as=1.755e-12 ad=1.71e-12 \
        ps=3.9e-06 pd=4.5e-06 m=1 region=sat
    \+475 (231 625 775 44) ami06N w=9e-07 l=6e-07 as=1.755e-12 ad=1.71e-12 \
        ps=3.9e-06 pd=4.5e-06 m=1 region=sat
    \+474 (234 625 798 44) ami06N w=9e-07 l=6e-07 as=1.755e-12 ad=1.71e-12 \
        ps=3.9e-06 pd=4.5e-06 m=1 region=sat
    \+473 (237 625 821 44) ami06N w=9e-07 l=6e-07 as=1.755e-12 ad=1.71e-12 \
        ps=3.9e-06 pd=4.5e-06 m=1 region=sat
    \+472 (231 626 776 44) ami06N w=9e-07 l=6e-07 as=1.755e-12 ad=1.71e-12 \
        ps=3.9e-06 pd=4.5e-06 m=1 region=sat
    \+471 (234 626 799 44) ami06N w=9e-07 l=6e-07 as=1.755e-12 ad=1.71e-12 \
        ps=3.9e-06 pd=4.5e-06 m=1 region=sat
    \+470 (237 626 822 44) ami06N w=9e-07 l=6e-07 as=1.755e-12 ad=1.71e-12 \
        ps=3.9e-06 pd=4.5e-06 m=1 region=sat
    \+469 (231 625 777 44) ami06N w=9e-07 l=6e-07 as=1.755e-12 ad=1.71e-12 \
        ps=3.9e-06 pd=4.5e-06 m=1 region=sat
    \+468 (234 625 800 44) ami06N w=9e-07 l=6e-07 as=1.755e-12 ad=1.71e-12 \
        ps=3.9e-06 pd=4.5e-06 m=1 region=sat
    \+467 (231 626 778 44) ami06N w=9e-07 l=6e-07 as=1.755e-12 ad=1.71e-12 \
        ps=3.9e-06 pd=4.5e-06 m=1 region=sat
    \+466 (234 626 801 44) ami06N w=9e-07 l=6e-07 as=1.755e-12 ad=1.71e-12 \
        ps=3.9e-06 pd=4.5e-06 m=1 region=sat
    \+465 (231 625 779 44) ami06N w=9e-07 l=6e-07 as=1.755e-12 ad=1.71e-12 \
        ps=3.9e-06 pd=4.5e-06 m=1 region=sat
    \+464 (235 625 802 44) ami06N w=9e-07 l=6e-07 as=1.755e-12 ad=1.71e-12 \
        ps=3.9e-06 pd=4.5e-06 m=1 region=sat
    \+463 (231 626 780 44) ami06N w=9e-07 l=6e-07 as=1.755e-12 ad=1.71e-12 \
        ps=3.9e-06 pd=4.5e-06 m=1 region=sat
    \+462 (235 625 803 44) ami06N w=9e-07 l=6e-07 as=1.755e-12 ad=1.71e-12 \
        ps=3.9e-06 pd=4.5e-06 m=1 region=sat
    \+461 (232 625 781 44) ami06N w=9e-07 l=6e-07 as=1.755e-12 ad=1.71e-12 \
        ps=3.9e-06 pd=4.5e-06 m=1 region=sat
    \+460 (235 626 804 44) ami06N w=9e-07 l=6e-07 as=1.755e-12 ad=1.71e-12 \
        ps=3.9e-06 pd=4.5e-06 m=1 region=sat
    \+459 (232 625 782 44) ami06N w=9e-07 l=6e-07 as=1.755e-12 ad=1.71e-12 \
        ps=3.9e-06 pd=4.5e-06 m=1 region=sat
    \+458 (235 625 805 44) ami06N w=9e-07 l=6e-07 as=1.755e-12 ad=1.71e-12 \
        ps=3.9e-06 pd=4.5e-06 m=1 region=sat
    \+457 (232 626 783 44) ami06N w=9e-07 l=6e-07 as=1.755e-12 ad=1.71e-12 \
        ps=3.9e-06 pd=4.5e-06 m=1 region=sat
    \+456 (235 626 806 44) ami06N w=9e-07 l=6e-07 as=1.755e-12 ad=1.71e-12 \
        ps=3.9e-06 pd=4.5e-06 m=1 region=sat
    \+455 (232 625 784 44) ami06N w=9e-07 l=6e-07 as=1.755e-12 ad=1.71e-12 \
        ps=3.9e-06 pd=4.5e-06 m=1 region=sat
    \+454 (235 625 807 44) ami06N w=9e-07 l=6e-07 as=1.755e-12 ad=1.71e-12 \
        ps=3.9e-06 pd=4.5e-06 m=1 region=sat
    \+453 (232 626 785 44) ami06N w=9e-07 l=6e-07 as=1.755e-12 ad=1.71e-12 \
        ps=3.9e-06 pd=4.5e-06 m=1 region=sat
    \+452 (235 626 808 44) ami06N w=9e-07 l=6e-07 as=1.755e-12 ad=1.71e-12 \
        ps=3.9e-06 pd=4.5e-06 m=1 region=sat
    \+451 (232 625 786 44) ami06N w=9e-07 l=6e-07 as=1.755e-12 ad=1.71e-12 \
        ps=3.9e-06 pd=4.5e-06 m=1 region=sat
    \+450 (236 625 809 44) ami06N w=9e-07 l=6e-07 as=1.755e-12 ad=1.71e-12 \
        ps=3.9e-06 pd=4.5e-06 m=1 region=sat
    \+449 (232 626 787 44) ami06N w=9e-07 l=6e-07 as=1.755e-12 ad=1.71e-12 \
        ps=3.9e-06 pd=4.5e-06 m=1 region=sat
    \+448 (236 625 810 44) ami06N w=9e-07 l=6e-07 as=1.755e-12 ad=1.71e-12 \
        ps=3.9e-06 pd=4.5e-06 m=1 region=sat
    \+447 (233 625 788 44) ami06N w=9e-07 l=6e-07 as=1.755e-12 ad=1.71e-12 \
        ps=3.9e-06 pd=4.5e-06 m=1 region=sat
    \+446 (236 626 811 44) ami06N w=9e-07 l=6e-07 as=1.755e-12 ad=1.71e-12 \
        ps=3.9e-06 pd=4.5e-06 m=1 region=sat
    \+444 (777 623 721 44) ami06N w=9e-07 l=6e-07 as=9.9e-13 ad=1.755e-12 \
        ps=2.1e-06 pd=3.9e-06 m=1 region=sat
    \+443 (800 624 744 44) ami06N w=9e-07 l=6e-07 as=9.9e-13 ad=1.755e-12 \
        ps=2.1e-06 pd=3.9e-06 m=1 region=sat
    \+442 (778 624 722 44) ami06N w=9e-07 l=6e-07 as=9.9e-13 ad=1.755e-12 \
        ps=2.1e-06 pd=3.9e-06 m=1 region=sat
    \+441 (801 624 745 44) ami06N w=9e-07 l=6e-07 as=9.9e-13 ad=1.755e-12 \
        ps=2.1e-06 pd=3.9e-06 m=1 region=sat
    \+440 (779 624 723 44) ami06N w=9e-07 l=6e-07 as=9.9e-13 ad=1.755e-12 \
        ps=2.1e-06 pd=3.9e-06 m=1 region=sat
    \+439 (802 623 746 44) ami06N w=9e-07 l=6e-07 as=9.9e-13 ad=1.755e-12 \
        ps=2.1e-06 pd=3.9e-06 m=1 region=sat
    \+438 (780 624 724 44) ami06N w=9e-07 l=6e-07 as=9.9e-13 ad=1.755e-12 \
        ps=2.1e-06 pd=3.9e-06 m=1 region=sat
    \+437 (803 624 747 44) ami06N w=9e-07 l=6e-07 as=9.9e-13 ad=1.755e-12 \
        ps=2.1e-06 pd=3.9e-06 m=1 region=sat
    \+436 (781 623 725 44) ami06N w=9e-07 l=6e-07 as=9.9e-13 ad=1.755e-12 \
        ps=2.1e-06 pd=3.9e-06 m=1 region=sat
    \+435 (804 623 748 44) ami06N w=9e-07 l=6e-07 as=9.9e-13 ad=1.755e-12 \
        ps=2.1e-06 pd=3.9e-06 m=1 region=sat
    \+434 (782 624 726 44) ami06N w=9e-07 l=6e-07 as=9.9e-13 ad=1.755e-12 \
        ps=2.1e-06 pd=3.9e-06 m=1 region=sat
    \+433 (805 623 749 44) ami06N w=9e-07 l=6e-07 as=9.9e-13 ad=1.755e-12 \
        ps=2.1e-06 pd=3.9e-06 m=1 region=sat
    \+432 (783 623 727 44) ami06N w=9e-07 l=6e-07 as=9.9e-13 ad=1.755e-12 \
        ps=2.1e-06 pd=3.9e-06 m=1 region=sat
    \+431 (806 624 750 44) ami06N w=9e-07 l=6e-07 as=9.9e-13 ad=1.755e-12 \
        ps=2.1e-06 pd=3.9e-06 m=1 region=sat
    \+430 (784 623 728 44) ami06N w=9e-07 l=6e-07 as=9.9e-13 ad=1.755e-12 \
        ps=2.1e-06 pd=3.9e-06 m=1 region=sat
    \+429 (807 624 751 44) ami06N w=9e-07 l=6e-07 as=9.9e-13 ad=1.755e-12 \
        ps=2.1e-06 pd=3.9e-06 m=1 region=sat
    \+428 (785 624 729 44) ami06N w=9e-07 l=6e-07 as=9.9e-13 ad=1.755e-12 \
        ps=2.1e-06 pd=3.9e-06 m=1 region=sat
    \+427 (808 624 752 44) ami06N w=9e-07 l=6e-07 as=9.9e-13 ad=1.755e-12 \
        ps=2.1e-06 pd=3.9e-06 m=1 region=sat
    \+426 (786 624 730 44) ami06N w=9e-07 l=6e-07 as=9.9e-13 ad=1.755e-12 \
        ps=2.1e-06 pd=3.9e-06 m=1 region=sat
    \+425 (809 623 753 44) ami06N w=9e-07 l=6e-07 as=9.9e-13 ad=1.755e-12 \
        ps=2.1e-06 pd=3.9e-06 m=1 region=sat
    \+424 (787 624 731 44) ami06N w=9e-07 l=6e-07 as=9.9e-13 ad=1.755e-12 \
        ps=2.1e-06 pd=3.9e-06 m=1 region=sat
    \+423 (810 624 754 44) ami06N w=9e-07 l=6e-07 as=9.9e-13 ad=1.755e-12 \
        ps=2.1e-06 pd=3.9e-06 m=1 region=sat
    \+422 (788 623 732 44) ami06N w=9e-07 l=6e-07 as=9.9e-13 ad=1.755e-12 \
        ps=2.1e-06 pd=3.9e-06 m=1 region=sat
    \+421 (811 623 755 44) ami06N w=9e-07 l=6e-07 as=9.9e-13 ad=1.755e-12 \
        ps=2.1e-06 pd=3.9e-06 m=1 region=sat
    \+420 (789 624 733 44) ami06N w=9e-07 l=6e-07 as=9.9e-13 ad=1.755e-12 \
        ps=2.1e-06 pd=3.9e-06 m=1 region=sat
    \+419 (812 623 756 44) ami06N w=9e-07 l=6e-07 as=9.9e-13 ad=1.755e-12 \
        ps=2.1e-06 pd=3.9e-06 m=1 region=sat
    \+418 (767 623 711 44) ami06N w=9e-07 l=6e-07 as=9.9e-13 ad=1.755e-12 \
        ps=2.1e-06 pd=3.9e-06 m=1 region=sat
    \+417 (790 623 734 44) ami06N w=9e-07 l=6e-07 as=9.9e-13 ad=1.755e-12 \
        ps=2.1e-06 pd=3.9e-06 m=1 region=sat
    \+416 (813 624 757 44) ami06N w=9e-07 l=6e-07 as=9.9e-13 ad=1.755e-12 \
        ps=2.1e-06 pd=3.9e-06 m=1 region=sat
    \+415 (768 624 712 44) ami06N w=9e-07 l=6e-07 as=9.9e-13 ad=1.755e-12 \
        ps=2.1e-06 pd=3.9e-06 m=1 region=sat
    \+414 (791 623 735 44) ami06N w=9e-07 l=6e-07 as=9.9e-13 ad=1.755e-12 \
        ps=2.1e-06 pd=3.9e-06 m=1 region=sat
    \+413 (814 624 758 44) ami06N w=9e-07 l=6e-07 as=9.9e-13 ad=1.755e-12 \
        ps=2.1e-06 pd=3.9e-06 m=1 region=sat
    \+412 (769 623 713 44) ami06N w=9e-07 l=6e-07 as=9.9e-13 ad=1.755e-12 \
        ps=2.1e-06 pd=3.9e-06 m=1 region=sat
    \+411 (792 624 736 44) ami06N w=9e-07 l=6e-07 as=9.9e-13 ad=1.755e-12 \
        ps=2.1e-06 pd=3.9e-06 m=1 region=sat
    \+410 (815 624 759 44) ami06N w=9e-07 l=6e-07 as=9.9e-13 ad=1.755e-12 \
        ps=2.1e-06 pd=3.9e-06 m=1 region=sat
    \+409 (770 623 714 44) ami06N w=9e-07 l=6e-07 as=9.9e-13 ad=1.755e-12 \
        ps=2.1e-06 pd=3.9e-06 m=1 region=sat
    \+408 (793 624 737 44) ami06N w=9e-07 l=6e-07 as=9.9e-13 ad=1.755e-12 \
        ps=2.1e-06 pd=3.9e-06 m=1 region=sat
    \+407 (816 623 760 44) ami06N w=9e-07 l=6e-07 as=9.9e-13 ad=1.755e-12 \
        ps=2.1e-06 pd=3.9e-06 m=1 region=sat
    \+406 (771 624 715 44) ami06N w=9e-07 l=6e-07 as=9.9e-13 ad=1.755e-12 \
        ps=2.1e-06 pd=3.9e-06 m=1 region=sat
    \+405 (794 624 738 44) ami06N w=9e-07 l=6e-07 as=9.9e-13 ad=1.755e-12 \
        ps=2.1e-06 pd=3.9e-06 m=1 region=sat
    \+404 (817 624 761 44) ami06N w=9e-07 l=6e-07 as=9.9e-13 ad=1.755e-12 \
        ps=2.1e-06 pd=3.9e-06 m=1 region=sat
    \+403 (772 624 716 44) ami06N w=9e-07 l=6e-07 as=9.9e-13 ad=1.755e-12 \
        ps=2.1e-06 pd=3.9e-06 m=1 region=sat
    \+402 (795 623 739 44) ami06N w=9e-07 l=6e-07 as=9.9e-13 ad=1.755e-12 \
        ps=2.1e-06 pd=3.9e-06 m=1 region=sat
    \+401 (818 623 762 44) ami06N w=9e-07 l=6e-07 as=9.9e-13 ad=1.755e-12 \
        ps=2.1e-06 pd=3.9e-06 m=1 region=sat
    \+400 (773 624 717 44) ami06N w=9e-07 l=6e-07 as=9.9e-13 ad=1.755e-12 \
        ps=2.1e-06 pd=3.9e-06 m=1 region=sat
    \+399 (796 624 740 44) ami06N w=9e-07 l=6e-07 as=9.9e-13 ad=1.755e-12 \
        ps=2.1e-06 pd=3.9e-06 m=1 region=sat
    \+398 (819 623 763 44) ami06N w=9e-07 l=6e-07 as=9.9e-13 ad=1.755e-12 \
        ps=2.1e-06 pd=3.9e-06 m=1 region=sat
    \+397 (774 623 718 44) ami06N w=9e-07 l=6e-07 as=9.9e-13 ad=1.755e-12 \
        ps=2.1e-06 pd=3.9e-06 m=1 region=sat
    \+396 (797 623 741 44) ami06N w=9e-07 l=6e-07 as=9.9e-13 ad=1.755e-12 \
        ps=2.1e-06 pd=3.9e-06 m=1 region=sat
    \+395 (820 624 764 44) ami06N w=9e-07 l=6e-07 as=9.9e-13 ad=1.755e-12 \
        ps=2.1e-06 pd=3.9e-06 m=1 region=sat
    \+394 (775 624 719 44) ami06N w=9e-07 l=6e-07 as=9.9e-13 ad=1.755e-12 \
        ps=2.1e-06 pd=3.9e-06 m=1 region=sat
    \+393 (798 623 742 44) ami06N w=9e-07 l=6e-07 as=9.9e-13 ad=1.755e-12 \
        ps=2.1e-06 pd=3.9e-06 m=1 region=sat
    \+392 (821 624 765 44) ami06N w=9e-07 l=6e-07 as=9.9e-13 ad=1.755e-12 \
        ps=2.1e-06 pd=3.9e-06 m=1 region=sat
    \+391 (776 623 720 44) ami06N w=9e-07 l=6e-07 as=9.9e-13 ad=1.755e-12 \
        ps=2.1e-06 pd=3.9e-06 m=1 region=sat
    \+390 (799 624 743 44) ami06N w=9e-07 l=6e-07 as=9.9e-13 ad=1.755e-12 \
        ps=2.1e-06 pd=3.9e-06 m=1 region=sat
    \+389 (822 624 766 44) ami06N w=9e-07 l=6e-07 as=9.9e-13 ad=1.755e-12 \
        ps=2.1e-06 pd=3.9e-06 m=1 region=sat
    \+387 (755 621 202 44) ami06N w=9e-07 l=6e-07 as=1.71e-12 ad=9.9e-13 \
        ps=4.5e-06 pd=2.1e-06 m=1 region=sat
    \+386 (732 621 224 44) ami06N w=9e-07 l=6e-07 as=1.71e-12 ad=9.9e-13 \
        ps=4.5e-06 pd=2.1e-06 m=1 region=sat
    \+385 (733 621 216 44) ami06N w=9e-07 l=6e-07 as=1.71e-12 ad=9.9e-13 \
        ps=4.5e-06 pd=2.1e-06 m=1 region=sat
    \+384 (756 622 210 44) ami06N w=9e-07 l=6e-07 as=1.71e-12 ad=9.9e-13 \
        ps=4.5e-06 pd=2.1e-06 m=1 region=sat
    \+383 (734 621 199 44) ami06N w=9e-07 l=6e-07 as=1.71e-12 ad=9.9e-13 \
        ps=4.5e-06 pd=2.1e-06 m=1 region=sat
    \+382 (711 621 221 44) ami06N w=9e-07 l=6e-07 as=1.71e-12 ad=9.9e-13 \
        ps=4.5e-06 pd=2.1e-06 m=1 region=sat
    \+381 (757 621 176 44) ami06N w=9e-07 l=6e-07 as=1.71e-12 ad=9.9e-13 \
        ps=4.5e-06 pd=2.1e-06 m=1 region=sat
    \+380 (735 622 207 44) ami06N w=9e-07 l=6e-07 as=1.71e-12 ad=9.9e-13 \
        ps=4.5e-06 pd=2.1e-06 m=1 region=sat
    \+379 (712 621 213 44) ami06N w=9e-07 l=6e-07 as=1.71e-12 ad=9.9e-13 \
        ps=4.5e-06 pd=2.1e-06 m=1 region=sat
    \+378 (758 622 168 44) ami06N w=9e-07 l=6e-07 as=1.71e-12 ad=9.9e-13 \
        ps=4.5e-06 pd=2.1e-06 m=1 region=sat
    \+377 (736 621 173 44) ami06N w=9e-07 l=6e-07 as=1.71e-12 ad=9.9e-13 \
        ps=4.5e-06 pd=2.1e-06 m=1 region=sat
    \+376 (713 621 196 44) ami06N w=9e-07 l=6e-07 as=1.71e-12 ad=9.9e-13 \
        ps=4.5e-06 pd=2.1e-06 m=1 region=sat
    \+375 (759 622 57 44) ami06N w=9e-07 l=6e-07 as=1.71e-12 ad=9.9e-13 \
        ps=4.5e-06 pd=2.1e-06 m=1 region=sat
    \+374 (737 622 165 44) ami06N w=9e-07 l=6e-07 as=1.71e-12 ad=9.9e-13 \
        ps=4.5e-06 pd=2.1e-06 m=1 region=sat
    \+373 (714 622 204 44) ami06N w=9e-07 l=6e-07 as=1.71e-12 ad=9.9e-13 \
        ps=4.5e-06 pd=2.1e-06 m=1 region=sat
    \+372 (760 621 228 44) ami06N w=9e-07 l=6e-07 as=1.71e-12 ad=9.9e-13 \
        ps=4.5e-06 pd=2.1e-06 m=1 region=sat
    \+371 (738 622 51 44) ami06N w=9e-07 l=6e-07 as=1.71e-12 ad=9.9e-13 \
        ps=4.5e-06 pd=2.1e-06 m=1 region=sat
    \+370 (715 621 170 44) ami06N w=9e-07 l=6e-07 as=1.71e-12 ad=9.9e-13 \
        ps=4.5e-06 pd=2.1e-06 m=1 region=sat
    \+369 (761 621 220 44) ami06N w=9e-07 l=6e-07 as=1.71e-12 ad=9.9e-13 \
        ps=4.5e-06 pd=2.1e-06 m=1 region=sat
    \+368 (716 622 162 44) ami06N w=9e-07 l=6e-07 as=1.71e-12 ad=9.9e-13 \
        ps=4.5e-06 pd=2.1e-06 m=1 region=sat
    \+367 (739 621 225 44) ami06N w=9e-07 l=6e-07 as=1.71e-12 ad=9.9e-13 \
        ps=4.5e-06 pd=2.1e-06 m=1 region=sat
    \+366 (762 621 203 44) ami06N w=9e-07 l=6e-07 as=1.71e-12 ad=9.9e-13 \
        ps=4.5e-06 pd=2.1e-06 m=1 region=sat
    \+365 (740 621 217 44) ami06N w=9e-07 l=6e-07 as=1.71e-12 ad=9.9e-13 \
        ps=4.5e-06 pd=2.1e-06 m=1 region=sat
    \+364 (717 622 45 44) ami06N w=9e-07 l=6e-07 as=1.71e-12 ad=9.9e-13 \
        ps=4.5e-06 pd=2.1e-06 m=1 region=sat
    \+363 (763 622 211 44) ami06N w=9e-07 l=6e-07 as=1.71e-12 ad=9.9e-13 \
        ps=4.5e-06 pd=2.1e-06 m=1 region=sat
    \+362 (741 621 200 44) ami06N w=9e-07 l=6e-07 as=1.71e-12 ad=9.9e-13 \
        ps=4.5e-06 pd=2.1e-06 m=1 region=sat
    \+361 (718 621 222 44) ami06N w=9e-07 l=6e-07 as=1.71e-12 ad=9.9e-13 \
        ps=4.5e-06 pd=2.1e-06 m=1 region=sat
    \+360 (764 621 177 44) ami06N w=9e-07 l=6e-07 as=1.71e-12 ad=9.9e-13 \
        ps=4.5e-06 pd=2.1e-06 m=1 region=sat
    \+359 (742 622 208 44) ami06N w=9e-07 l=6e-07 as=1.71e-12 ad=9.9e-13 \
        ps=4.5e-06 pd=2.1e-06 m=1 region=sat
    \+358 (719 621 214 44) ami06N w=9e-07 l=6e-07 as=1.71e-12 ad=9.9e-13 \
        ps=4.5e-06 pd=2.1e-06 m=1 region=sat
    \+357 (765 622 169 44) ami06N w=9e-07 l=6e-07 as=1.71e-12 ad=9.9e-13 \
        ps=4.5e-06 pd=2.1e-06 m=1 region=sat
    \+356 (743 621 174 44) ami06N w=9e-07 l=6e-07 as=1.71e-12 ad=9.9e-13 \
        ps=4.5e-06 pd=2.1e-06 m=1 region=sat
    \+355 (720 621 197 44) ami06N w=9e-07 l=6e-07 as=1.71e-12 ad=9.9e-13 \
        ps=4.5e-06 pd=2.1e-06 m=1 region=sat
    \+354 (766 622 59 44) ami06N w=9e-07 l=6e-07 as=1.71e-12 ad=9.9e-13 \
        ps=4.5e-06 pd=2.1e-06 m=1 region=sat
    \+353 (744 622 166 44) ami06N w=9e-07 l=6e-07 as=1.71e-12 ad=9.9e-13 \
        ps=4.5e-06 pd=2.1e-06 m=1 region=sat
    \+352 (721 622 205 44) ami06N w=9e-07 l=6e-07 as=1.71e-12 ad=9.9e-13 \
        ps=4.5e-06 pd=2.1e-06 m=1 region=sat
    \+351 (745 622 53 44) ami06N w=9e-07 l=6e-07 as=1.71e-12 ad=9.9e-13 \
        ps=4.5e-06 pd=2.1e-06 m=1 region=sat
    \+350 (722 621 171 44) ami06N w=9e-07 l=6e-07 as=1.71e-12 ad=9.9e-13 \
        ps=4.5e-06 pd=2.1e-06 m=1 region=sat
    \+349 (746 621 226 44) ami06N w=9e-07 l=6e-07 as=1.71e-12 ad=9.9e-13 \
        ps=4.5e-06 pd=2.1e-06 m=1 region=sat
    \+348 (723 622 163 44) ami06N w=9e-07 l=6e-07 as=1.71e-12 ad=9.9e-13 \
        ps=4.5e-06 pd=2.1e-06 m=1 region=sat
    \+347 (747 621 218 44) ami06N w=9e-07 l=6e-07 as=1.71e-12 ad=9.9e-13 \
        ps=4.5e-06 pd=2.1e-06 m=1 region=sat
    \+346 (724 622 47 44) ami06N w=9e-07 l=6e-07 as=1.71e-12 ad=9.9e-13 \
        ps=4.5e-06 pd=2.1e-06 m=1 region=sat
    \+345 (748 621 201 44) ami06N w=9e-07 l=6e-07 as=1.71e-12 ad=9.9e-13 \
        ps=4.5e-06 pd=2.1e-06 m=1 region=sat
    \+344 (725 621 223 44) ami06N w=9e-07 l=6e-07 as=1.71e-12 ad=9.9e-13 \
        ps=4.5e-06 pd=2.1e-06 m=1 region=sat
    \+343 (749 622 209 44) ami06N w=9e-07 l=6e-07 as=1.71e-12 ad=9.9e-13 \
        ps=4.5e-06 pd=2.1e-06 m=1 region=sat
    \+342 (726 621 215 44) ami06N w=9e-07 l=6e-07 as=1.71e-12 ad=9.9e-13 \
        ps=4.5e-06 pd=2.1e-06 m=1 region=sat
    \+341 (727 621 198 44) ami06N w=9e-07 l=6e-07 as=1.71e-12 ad=9.9e-13 \
        ps=4.5e-06 pd=2.1e-06 m=1 region=sat
    \+340 (750 621 175 44) ami06N w=9e-07 l=6e-07 as=1.71e-12 ad=9.9e-13 \
        ps=4.5e-06 pd=2.1e-06 m=1 region=sat
    \+339 (751 622 167 44) ami06N w=9e-07 l=6e-07 as=1.71e-12 ad=9.9e-13 \
        ps=4.5e-06 pd=2.1e-06 m=1 region=sat
    \+338 (728 622 206 44) ami06N w=9e-07 l=6e-07 as=1.71e-12 ad=9.9e-13 \
        ps=4.5e-06 pd=2.1e-06 m=1 region=sat
    \+337 (752 622 55 44) ami06N w=9e-07 l=6e-07 as=1.71e-12 ad=9.9e-13 \
        ps=4.5e-06 pd=2.1e-06 m=1 region=sat
    \+336 (729 621 172 44) ami06N w=9e-07 l=6e-07 as=1.71e-12 ad=9.9e-13 \
        ps=4.5e-06 pd=2.1e-06 m=1 region=sat
    \+335 (753 621 227 44) ami06N w=9e-07 l=6e-07 as=1.71e-12 ad=9.9e-13 \
        ps=4.5e-06 pd=2.1e-06 m=1 region=sat
    \+334 (730 622 164 44) ami06N w=9e-07 l=6e-07 as=1.71e-12 ad=9.9e-13 \
        ps=4.5e-06 pd=2.1e-06 m=1 region=sat
    \+333 (754 621 219 44) ami06N w=9e-07 l=6e-07 as=1.71e-12 ad=9.9e-13 \
        ps=4.5e-06 pd=2.1e-06 m=1 region=sat
    \+332 (731 622 49 44) ami06N w=9e-07 l=6e-07 as=1.71e-12 ad=9.9e-13 \
        ps=4.5e-06 pd=2.1e-06 m=1 region=sat
    \+322 (205 189 44 44) ami06N w=9e-07 l=6e-07 as=1.71e-12 ad=1.71e-12 \
        ps=4.5e-06 pd=4.5e-06 m=1 region=sat
    \+321 (206 190 44 44) ami06N w=9e-07 l=6e-07 as=1.71e-12 ad=1.71e-12 \
        ps=4.5e-06 pd=4.5e-06 m=1 region=sat
    \+320 (207 191 44 44) ami06N w=9e-07 l=6e-07 as=1.71e-12 ad=1.71e-12 \
        ps=4.5e-06 pd=4.5e-06 m=1 region=sat
    \+319 (208 192 44 44) ami06N w=9e-07 l=6e-07 as=1.71e-12 ad=1.71e-12 \
        ps=4.5e-06 pd=4.5e-06 m=1 region=sat
    \+318 (209 193 44 44) ami06N w=9e-07 l=6e-07 as=1.71e-12 ad=1.71e-12 \
        ps=4.5e-06 pd=4.5e-06 m=1 region=sat
    \+317 (210 194 44 44) ami06N w=9e-07 l=6e-07 as=1.71e-12 ad=1.71e-12 \
        ps=4.5e-06 pd=4.5e-06 m=1 region=sat
    \+316 (211 195 44 44) ami06N w=9e-07 l=6e-07 as=1.71e-12 ad=1.71e-12 \
        ps=4.5e-06 pd=4.5e-06 m=1 region=sat
    \+315 (204 188 44 44) ami06N w=9e-07 l=6e-07 as=1.71e-12 ad=1.71e-12 \
        ps=4.5e-06 pd=4.5e-06 m=1 region=sat
    \+314 (196 221 695 44) ami06N w=9e-07 l=6e-07 as=1.53e-12 ad=1.71e-12 \
        ps=3.15e-06 pd=4.5e-06 m=1 region=sat
    \+313 (197 222 697 44) ami06N w=9e-07 l=6e-07 as=1.53e-12 ad=1.71e-12 \
        ps=3.15e-06 pd=4.5e-06 m=1 region=sat
    \+312 (198 223 699 44) ami06N w=9e-07 l=6e-07 as=1.53e-12 ad=1.71e-12 \
        ps=3.15e-06 pd=4.5e-06 m=1 region=sat
    \+311 (199 224 701 44) ami06N w=9e-07 l=6e-07 as=1.53e-12 ad=1.71e-12 \
        ps=3.15e-06 pd=4.5e-06 m=1 region=sat
    \+310 (200 225 703 44) ami06N w=9e-07 l=6e-07 as=1.53e-12 ad=1.71e-12 \
        ps=3.15e-06 pd=4.5e-06 m=1 region=sat
    \+309 (201 226 705 44) ami06N w=9e-07 l=6e-07 as=1.53e-12 ad=1.71e-12 \
        ps=3.15e-06 pd=4.5e-06 m=1 region=sat
    \+308 (202 227 707 44) ami06N w=9e-07 l=6e-07 as=1.53e-12 ad=1.71e-12 \
        ps=3.15e-06 pd=4.5e-06 m=1 region=sat
    \+307 (203 228 709 44) ami06N w=9e-07 l=6e-07 as=1.53e-12 ad=1.71e-12 \
        ps=3.15e-06 pd=4.5e-06 m=1 region=sat
    \+306 (202 219 708 44) ami06N w=9e-07 l=6e-07 as=1.45125e-12 \
        ad=1.71e-12 ps=3e-06 pd=4.5e-06 m=1 region=sat
    \+305 (203 220 710 44) ami06N w=9e-07 l=6e-07 as=1.45125e-12 \
        ad=1.71e-12 ps=3e-06 pd=4.5e-06 m=1 region=sat
    \+304 (196 213 696 44) ami06N w=9e-07 l=6e-07 as=1.45125e-12 \
        ad=1.71e-12 ps=3e-06 pd=4.5e-06 m=1 region=sat
    \+303 (197 214 698 44) ami06N w=9e-07 l=6e-07 as=1.45125e-12 \
        ad=1.71e-12 ps=3e-06 pd=4.5e-06 m=1 region=sat
    \+302 (198 215 700 44) ami06N w=9e-07 l=6e-07 as=1.45125e-12 \
        ad=1.71e-12 ps=3e-06 pd=4.5e-06 m=1 region=sat
    \+301 (199 216 702 44) ami06N w=9e-07 l=6e-07 as=1.45125e-12 \
        ad=1.71e-12 ps=3e-06 pd=4.5e-06 m=1 region=sat
    \+300 (200 217 704 44) ami06N w=9e-07 l=6e-07 as=1.45125e-12 \
        ad=1.71e-12 ps=3e-06 pd=4.5e-06 m=1 region=sat
    \+299 (201 218 706 44) ami06N w=9e-07 l=6e-07 as=1.45125e-12 \
        ad=1.71e-12 ps=3e-06 pd=4.5e-06 m=1 region=sat
    \+289 (699 242 44 44) ami06N w=9e-07 l=6e-07 as=1.71e-12 ad=1.53e-12 \
        ps=4.5e-06 pd=3.15e-06 m=1 region=sat
    \+288 (193 226 692 44) ami06N w=9e-07 l=6e-07 as=9.9e-13 ad=1.71e-12 \
        ps=2.1e-06 pd=4.5e-06 m=1 region=sat
    \+287 (700 182 44 44) ami06N w=9e-07 l=6e-07 as=1.71e-12 \
        ad=1.45125e-12 ps=4.5e-06 pd=3e-06 m=1 region=sat
    \+286 (707 246 44 44) ami06N w=9e-07 l=6e-07 as=1.71e-12 ad=1.53e-12 \
        ps=4.5e-06 pd=3.15e-06 m=1 region=sat
    \+285 (190 223 689 44) ami06N w=9e-07 l=6e-07 as=9.9e-13 ad=1.71e-12 \
        ps=2.1e-06 pd=4.5e-06 m=1 region=sat
    \+284 (708 186 44 44) ami06N w=9e-07 l=6e-07 as=1.71e-12 \
        ad=1.45125e-12 ps=4.5e-06 pd=3e-06 m=1 region=sat
    \+283 (701 243 44 44) ami06N w=9e-07 l=6e-07 as=1.71e-12 ad=1.53e-12 \
        ps=4.5e-06 pd=3.15e-06 m=1 region=sat
    \+282 (194 227 693 44) ami06N w=9e-07 l=6e-07 as=9.9e-13 ad=1.71e-12 \
        ps=2.1e-06 pd=4.5e-06 m=1 region=sat
    \+281 (702 183 44 44) ami06N w=9e-07 l=6e-07 as=1.71e-12 \
        ad=1.45125e-12 ps=4.5e-06 pd=3e-06 m=1 region=sat
    \+280 (709 247 44 44) ami06N w=9e-07 l=6e-07 as=1.71e-12 ad=1.53e-12 \
        ps=4.5e-06 pd=3.15e-06 m=1 region=sat
    \+279 (695 240 44 44) ami06N w=9e-07 l=6e-07 as=1.71e-12 ad=1.53e-12 \
        ps=4.5e-06 pd=3.15e-06 m=1 region=sat
    \+278 (191 224 690 44) ami06N w=9e-07 l=6e-07 as=9.9e-13 ad=1.71e-12 \
        ps=2.1e-06 pd=4.5e-06 m=1 region=sat
    \+277 (710 187 44 44) ami06N w=9e-07 l=6e-07 as=1.71e-12 \
        ad=1.45125e-12 ps=4.5e-06 pd=3e-06 m=1 region=sat
    \+276 (696 180 44 44) ami06N w=9e-07 l=6e-07 as=1.71e-12 \
        ad=1.45125e-12 ps=4.5e-06 pd=3e-06 m=1 region=sat
    \+275 (703 244 44 44) ami06N w=9e-07 l=6e-07 as=1.71e-12 ad=1.53e-12 \
        ps=4.5e-06 pd=3.15e-06 m=1 region=sat
    \+274 (195 228 694 44) ami06N w=9e-07 l=6e-07 as=9.9e-13 ad=1.71e-12 \
        ps=2.1e-06 pd=4.5e-06 m=1 region=sat
    \+273 (188 221 687 44) ami06N w=9e-07 l=6e-07 as=9.9e-13 ad=1.71e-12 \
        ps=2.1e-06 pd=4.5e-06 m=1 region=sat
    \+272 (704 184 44 44) ami06N w=9e-07 l=6e-07 as=1.71e-12 \
        ad=1.45125e-12 ps=4.5e-06 pd=3e-06 m=1 region=sat
    \+271 (697 241 44 44) ami06N w=9e-07 l=6e-07 as=1.71e-12 ad=1.53e-12 \
        ps=4.5e-06 pd=3.15e-06 m=1 region=sat
    \+270 (192 225 691 44) ami06N w=9e-07 l=6e-07 as=9.9e-13 ad=1.71e-12 \
        ps=2.1e-06 pd=4.5e-06 m=1 region=sat
    \+269 (698 181 44 44) ami06N w=9e-07 l=6e-07 as=1.71e-12 \
        ad=1.45125e-12 ps=4.5e-06 pd=3e-06 m=1 region=sat
    \+268 (705 245 44 44) ami06N w=9e-07 l=6e-07 as=1.71e-12 ad=1.53e-12 \
        ps=4.5e-06 pd=3.15e-06 m=1 region=sat
    \+267 (189 222 688 44) ami06N w=9e-07 l=6e-07 as=9.9e-13 ad=1.71e-12 \
        ps=2.1e-06 pd=4.5e-06 m=1 region=sat
    \+266 (706 185 44 44) ami06N w=9e-07 l=6e-07 as=1.71e-12 \
        ad=1.45125e-12 ps=4.5e-06 pd=3e-06 m=1 region=sat
    \+265 (690 243 44 44) ami06N w=9e-07 l=6e-07 as=1.71e-12 ad=9.9e-13 \
        ps=4.5e-06 pd=2.1e-06 m=1 region=sat
    \+264 (691 244 44 44) ami06N w=9e-07 l=6e-07 as=1.71e-12 ad=9.9e-13 \
        ps=4.5e-06 pd=2.1e-06 m=1 region=sat
    \+263 (692 245 44 44) ami06N w=9e-07 l=6e-07 as=1.71e-12 ad=9.9e-13 \
        ps=4.5e-06 pd=2.1e-06 m=1 region=sat
    \+262 (693 246 44 44) ami06N w=9e-07 l=6e-07 as=1.71e-12 ad=9.9e-13 \
        ps=4.5e-06 pd=2.1e-06 m=1 region=sat
    \+261 (694 247 44 44) ami06N w=9e-07 l=6e-07 as=1.71e-12 ad=9.9e-13 \
        ps=4.5e-06 pd=2.1e-06 m=1 region=sat
    \+260 (687 240 44 44) ami06N w=9e-07 l=6e-07 as=1.71e-12 ad=9.9e-13 \
        ps=4.5e-06 pd=2.1e-06 m=1 region=sat
    \+259 (688 241 44 44) ami06N w=9e-07 l=6e-07 as=1.71e-12 ad=9.9e-13 \
        ps=4.5e-06 pd=2.1e-06 m=1 region=sat
    \+258 (689 242 44 44) ami06N w=9e-07 l=6e-07 as=1.71e-12 ad=9.9e-13 \
        ps=4.5e-06 pd=2.1e-06 m=1 region=sat
    \+255 (172 155 44 44) ami06N w=9e-07 l=6e-07 as=1.71e-12 ad=1.71e-12 \
        ps=4.5e-06 pd=4.5e-06 m=1 region=sat
    \+254 (173 156 44 44) ami06N w=9e-07 l=6e-07 as=1.71e-12 ad=1.71e-12 \
        ps=4.5e-06 pd=4.5e-06 m=1 region=sat
    \+253 (174 157 44 44) ami06N w=9e-07 l=6e-07 as=1.71e-12 ad=1.71e-12 \
        ps=4.5e-06 pd=4.5e-06 m=1 region=sat
    \+252 (175 158 44 44) ami06N w=9e-07 l=6e-07 as=1.71e-12 ad=1.71e-12 \
        ps=4.5e-06 pd=4.5e-06 m=1 region=sat
    \+251 (176 159 44 44) ami06N w=9e-07 l=6e-07 as=1.71e-12 ad=1.71e-12 \
        ps=4.5e-06 pd=4.5e-06 m=1 region=sat
    \+250 (177 160 44 44) ami06N w=9e-07 l=6e-07 as=1.71e-12 ad=1.71e-12 \
        ps=4.5e-06 pd=4.5e-06 m=1 region=sat
    \+249 (170 153 44 44) ami06N w=9e-07 l=6e-07 as=1.71e-12 ad=1.71e-12 \
        ps=4.5e-06 pd=4.5e-06 m=1 region=sat
    \+248 (171 154 44 44) ami06N w=9e-07 l=6e-07 as=1.71e-12 ad=1.71e-12 \
        ps=4.5e-06 pd=4.5e-06 m=1 region=sat
    \+247 (162 145 44 44) ami06N w=9e-07 l=6e-07 as=1.71e-12 ad=1.71e-12 \
        ps=4.5e-06 pd=4.5e-06 m=1 region=sat
    \+246 (163 146 44 44) ami06N w=9e-07 l=6e-07 as=1.71e-12 ad=1.71e-12 \
        ps=4.5e-06 pd=4.5e-06 m=1 region=sat
    \+245 (164 147 44 44) ami06N w=9e-07 l=6e-07 as=1.71e-12 ad=1.71e-12 \
        ps=4.5e-06 pd=4.5e-06 m=1 region=sat
    \+244 (165 148 44 44) ami06N w=9e-07 l=6e-07 as=1.71e-12 ad=1.71e-12 \
        ps=4.5e-06 pd=4.5e-06 m=1 region=sat
    \+243 (166 149 44 44) ami06N w=9e-07 l=6e-07 as=1.71e-12 ad=1.71e-12 \
        ps=4.5e-06 pd=4.5e-06 m=1 region=sat
    \+242 (167 150 44 44) ami06N w=9e-07 l=6e-07 as=1.71e-12 ad=1.71e-12 \
        ps=4.5e-06 pd=4.5e-06 m=1 region=sat
    \+241 (168 151 44 44) ami06N w=9e-07 l=6e-07 as=1.71e-12 ad=1.71e-12 \
        ps=4.5e-06 pd=4.5e-06 m=1 region=sat
    \+240 (169 152 44 44) ami06N w=9e-07 l=6e-07 as=1.71e-12 ad=1.71e-12 \
        ps=4.5e-06 pd=4.5e-06 m=1 region=sat
    \+238 (153 221 44 44) ami06N w=9e-07 l=6e-07 as=9.9e-13 ad=1.71e-12 \
        ps=2.1e-06 pd=4.5e-06 m=1 region=sat
    \+237 (154 222 44 44) ami06N w=9e-07 l=6e-07 as=9.9e-13 ad=1.71e-12 \
        ps=2.1e-06 pd=4.5e-06 m=1 region=sat
    \+236 (155 223 44 44) ami06N w=9e-07 l=6e-07 as=9.9e-13 ad=1.71e-12 \
        ps=2.1e-06 pd=4.5e-06 m=1 region=sat
    \+235 (156 224 44 44) ami06N w=9e-07 l=6e-07 as=9.9e-13 ad=1.71e-12 \
        ps=2.1e-06 pd=4.5e-06 m=1 region=sat
    \+234 (157 225 44 44) ami06N w=9e-07 l=6e-07 as=9.9e-13 ad=1.71e-12 \
        ps=2.1e-06 pd=4.5e-06 m=1 region=sat
    \+233 (158 226 44 44) ami06N w=9e-07 l=6e-07 as=9.9e-13 ad=1.71e-12 \
        ps=2.1e-06 pd=4.5e-06 m=1 region=sat
    \+232 (159 227 44 44) ami06N w=9e-07 l=6e-07 as=9.9e-13 ad=1.71e-12 \
        ps=2.1e-06 pd=4.5e-06 m=1 region=sat
    \+231 (160 228 44 44) ami06N w=9e-07 l=6e-07 as=9.9e-13 ad=1.71e-12 \
        ps=2.1e-06 pd=4.5e-06 m=1 region=sat
    \+230 (44 245 158 44) ami06N w=9e-07 l=6e-07 as=1.71e-12 ad=9.9e-13 \
        ps=4.5e-06 pd=2.1e-06 m=1 region=sat
    \+229 (44 246 159 44) ami06N w=9e-07 l=6e-07 as=1.71e-12 ad=9.9e-13 \
        ps=4.5e-06 pd=2.1e-06 m=1 region=sat
    \+228 (44 247 160 44) ami06N w=9e-07 l=6e-07 as=1.71e-12 ad=9.9e-13 \
        ps=4.5e-06 pd=2.1e-06 m=1 region=sat
    \+227 (44 240 153 44) ami06N w=9e-07 l=6e-07 as=1.71e-12 ad=9.9e-13 \
        ps=4.5e-06 pd=2.1e-06 m=1 region=sat
    \+226 (44 241 154 44) ami06N w=9e-07 l=6e-07 as=1.71e-12 ad=9.9e-13 \
        ps=4.5e-06 pd=2.1e-06 m=1 region=sat
    \+225 (44 242 155 44) ami06N w=9e-07 l=6e-07 as=1.71e-12 ad=9.9e-13 \
        ps=4.5e-06 pd=2.1e-06 m=1 region=sat
    \+224 (44 243 156 44) ami06N w=9e-07 l=6e-07 as=1.71e-12 ad=9.9e-13 \
        ps=4.5e-06 pd=2.1e-06 m=1 region=sat
    \+223 (44 244 157 44) ami06N w=9e-07 l=6e-07 as=1.71e-12 ad=9.9e-13 \
        ps=4.5e-06 pd=2.1e-06 m=1 region=sat
    \+221 (148 123 131 44) ami06N w=9e-07 l=6e-07 as=1.71e-12 ad=1.71e-12 \
        ps=4.5e-06 pd=4.5e-06 m=1 region=sat
    \+220 (149 124 132 44) ami06N w=9e-07 l=6e-07 as=1.71e-12 ad=1.71e-12 \
        ps=4.5e-06 pd=4.5e-06 m=1 region=sat
    \+219 (150 125 133 44) ami06N w=9e-07 l=6e-07 as=1.71e-12 ad=1.71e-12 \
        ps=4.5e-06 pd=4.5e-06 m=1 region=sat
    \+218 (151 126 134 44) ami06N w=9e-07 l=6e-07 as=1.71e-12 ad=1.71e-12 \
        ps=4.5e-06 pd=4.5e-06 m=1 region=sat
    \+217 (152 127 135 44) ami06N w=9e-07 l=6e-07 as=1.71e-12 ad=1.71e-12 \
        ps=4.5e-06 pd=4.5e-06 m=1 region=sat
    \+216 (145 120 128 44) ami06N w=9e-07 l=6e-07 as=1.71e-12 ad=1.71e-12 \
        ps=4.5e-06 pd=4.5e-06 m=1 region=sat
    \+215 (146 121 129 44) ami06N w=9e-07 l=6e-07 as=1.71e-12 ad=1.71e-12 \
        ps=4.5e-06 pd=4.5e-06 m=1 region=sat
    \+214 (147 122 130 44) ami06N w=9e-07 l=6e-07 as=1.71e-12 ad=1.71e-12 \
        ps=4.5e-06 pd=4.5e-06 m=1 region=sat
    \+213 (149 244 683 44) ami06N w=9e-07 l=6e-07 as=1.485e-12 ad=1.71e-12 \
        ps=3.3e-06 pd=4.5e-06 m=1 region=sat
    \+212 (44 244 132 44) ami06N w=9e-07 l=6e-07 as=1.89e-12 ad=1.71e-12 \
        ps=3.6e-06 pd=4.5e-06 m=1 region=sat
    \+211 (150 245 684 44) ami06N w=9e-07 l=6e-07 as=1.485e-12 ad=1.71e-12 \
        ps=3.3e-06 pd=4.5e-06 m=1 region=sat
    \+210 (145 240 679 44) ami06N w=9e-07 l=6e-07 as=1.485e-12 ad=1.71e-12 \
        ps=3.3e-06 pd=4.5e-06 m=1 region=sat
    \+209 (44 245 133 44) ami06N w=9e-07 l=6e-07 as=1.89e-12 ad=1.71e-12 \
        ps=3.6e-06 pd=4.5e-06 m=1 region=sat
    \+208 (44 240 128 44) ami06N w=9e-07 l=6e-07 as=1.89e-12 ad=1.71e-12 \
        ps=3.6e-06 pd=4.5e-06 m=1 region=sat
    \+207 (151 246 685 44) ami06N w=9e-07 l=6e-07 as=1.485e-12 ad=1.71e-12 \
        ps=3.3e-06 pd=4.5e-06 m=1 region=sat
    \+206 (146 241 680 44) ami06N w=9e-07 l=6e-07 as=1.485e-12 ad=1.71e-12 \
        ps=3.3e-06 pd=4.5e-06 m=1 region=sat
    \+205 (44 246 134 44) ami06N w=9e-07 l=6e-07 as=1.89e-12 ad=1.71e-12 \
        ps=3.6e-06 pd=4.5e-06 m=1 region=sat
    \+204 (44 241 129 44) ami06N w=9e-07 l=6e-07 as=1.89e-12 ad=1.71e-12 \
        ps=3.6e-06 pd=4.5e-06 m=1 region=sat
    \+203 (152 247 686 44) ami06N w=9e-07 l=6e-07 as=1.485e-12 ad=1.71e-12 \
        ps=3.3e-06 pd=4.5e-06 m=1 region=sat
    \+202 (147 242 681 44) ami06N w=9e-07 l=6e-07 as=1.485e-12 ad=1.71e-12 \
        ps=3.3e-06 pd=4.5e-06 m=1 region=sat
    \+201 (44 247 135 44) ami06N w=9e-07 l=6e-07 as=1.89e-12 ad=1.71e-12 \
        ps=3.6e-06 pd=4.5e-06 m=1 region=sat
    \+200 (44 242 130 44) ami06N w=9e-07 l=6e-07 as=1.89e-12 ad=1.71e-12 \
        ps=3.6e-06 pd=4.5e-06 m=1 region=sat
    \+199 (148 243 682 44) ami06N w=9e-07 l=6e-07 as=1.485e-12 ad=1.71e-12 \
        ps=3.3e-06 pd=4.5e-06 m=1 region=sat
    \+198 (44 243 131 44) ami06N w=9e-07 l=6e-07 as=1.89e-12 ad=1.71e-12 \
        ps=3.6e-06 pd=4.5e-06 m=1 region=sat
    \+189 (684 226 676 44) ami06N w=9e-07 l=6e-07 as=8.1e-13 ad=1.485e-12 \
        ps=1.8e-06 pd=3.3e-06 m=1 region=sat
    \+188 (679 221 671 44) ami06N w=9e-07 l=6e-07 as=8.1e-13 ad=1.485e-12 \
        ps=1.8e-06 pd=3.3e-06 m=1 region=sat
    \+187 (133 226 44 44) ami06N w=9e-07 l=6e-07 as=9.9e-13 ad=1.89e-12 \
        ps=2.1e-06 pd=3.6e-06 m=1 region=sat
    \+186 (128 221 44 44) ami06N w=9e-07 l=6e-07 as=9.9e-13 ad=1.89e-12 \
        ps=2.1e-06 pd=3.6e-06 m=1 region=sat
    \+185 (685 227 677 44) ami06N w=9e-07 l=6e-07 as=8.1e-13 ad=1.485e-12 \
        ps=1.8e-06 pd=3.3e-06 m=1 region=sat
    \+184 (680 222 672 44) ami06N w=9e-07 l=6e-07 as=8.1e-13 ad=1.485e-12 \
        ps=1.8e-06 pd=3.3e-06 m=1 region=sat
    \+183 (134 227 44 44) ami06N w=9e-07 l=6e-07 as=9.9e-13 ad=1.89e-12 \
        ps=2.1e-06 pd=3.6e-06 m=1 region=sat
    \+182 (129 222 44 44) ami06N w=9e-07 l=6e-07 as=9.9e-13 ad=1.89e-12 \
        ps=2.1e-06 pd=3.6e-06 m=1 region=sat
    \+181 (686 228 678 44) ami06N w=9e-07 l=6e-07 as=8.1e-13 ad=1.485e-12 \
        ps=1.8e-06 pd=3.3e-06 m=1 region=sat
    \+180 (681 223 673 44) ami06N w=9e-07 l=6e-07 as=8.1e-13 ad=1.485e-12 \
        ps=1.8e-06 pd=3.3e-06 m=1 region=sat
    \+179 (135 228 44 44) ami06N w=9e-07 l=6e-07 as=9.9e-13 ad=1.89e-12 \
        ps=2.1e-06 pd=3.6e-06 m=1 region=sat
    \+178 (130 223 44 44) ami06N w=9e-07 l=6e-07 as=9.9e-13 ad=1.89e-12 \
        ps=2.1e-06 pd=3.6e-06 m=1 region=sat
    \+177 (682 224 674 44) ami06N w=9e-07 l=6e-07 as=8.1e-13 ad=1.485e-12 \
        ps=1.8e-06 pd=3.3e-06 m=1 region=sat
    \+176 (131 224 44 44) ami06N w=9e-07 l=6e-07 as=9.9e-13 ad=1.89e-12 \
        ps=2.1e-06 pd=3.6e-06 m=1 region=sat
    \+175 (683 225 675 44) ami06N w=9e-07 l=6e-07 as=8.1e-13 ad=1.485e-12 \
        ps=1.8e-06 pd=3.3e-06 m=1 region=sat
    \+174 (132 225 44 44) ami06N w=9e-07 l=6e-07 as=9.9e-13 ad=1.89e-12 \
        ps=2.1e-06 pd=3.6e-06 m=1 region=sat
    \+173 (673 138 44 44) ami06N w=9e-07 l=6e-07 as=1.71e-12 ad=8.1e-13 \
        ps=4.5e-06 pd=1.8e-06 m=1 region=sat
    \+172 (44 143 135 44) ami06N w=9e-07 l=6e-07 as=1.71e-12 ad=9.9e-13 \
        ps=4.5e-06 pd=2.1e-06 m=1 region=sat
    \+171 (44 138 130 44) ami06N w=9e-07 l=6e-07 as=1.71e-12 ad=9.9e-13 \
        ps=4.5e-06 pd=2.1e-06 m=1 region=sat
    \+170 (674 139 44 44) ami06N w=9e-07 l=6e-07 as=1.71e-12 ad=8.1e-13 \
        ps=4.5e-06 pd=1.8e-06 m=1 region=sat
    \+169 (44 139 131 44) ami06N w=9e-07 l=6e-07 as=1.71e-12 ad=9.9e-13 \
        ps=4.5e-06 pd=2.1e-06 m=1 region=sat
    \+168 (675 140 44 44) ami06N w=9e-07 l=6e-07 as=1.71e-12 ad=8.1e-13 \
        ps=4.5e-06 pd=1.8e-06 m=1 region=sat
    \+167 (44 140 132 44) ami06N w=9e-07 l=6e-07 as=1.71e-12 ad=9.9e-13 \
        ps=4.5e-06 pd=2.1e-06 m=1 region=sat
    \+166 (676 141 44 44) ami06N w=9e-07 l=6e-07 as=1.71e-12 ad=8.1e-13 \
        ps=4.5e-06 pd=1.8e-06 m=1 region=sat
    \+165 (671 44 44 44) ami06N w=9e-07 l=6e-07 as=1.71e-12 ad=8.1e-13 \
        ps=4.5e-06 pd=1.8e-06 m=1 region=sat
    \+164 (44 141 133 44) ami06N w=9e-07 l=6e-07 as=1.71e-12 ad=9.9e-13 \
        ps=4.5e-06 pd=2.1e-06 m=1 region=sat
    \+163 (44 44 128 44) ami06N w=9e-07 l=6e-07 as=1.71e-12 ad=9.9e-13 \
        ps=4.5e-06 pd=2.1e-06 m=1 region=sat
    \+162 (677 142 44 44) ami06N w=9e-07 l=6e-07 as=1.71e-12 ad=8.1e-13 \
        ps=4.5e-06 pd=1.8e-06 m=1 region=sat
    \+161 (672 137 44 44) ami06N w=9e-07 l=6e-07 as=1.71e-12 ad=8.1e-13 \
        ps=4.5e-06 pd=1.8e-06 m=1 region=sat
    \+160 (44 142 134 44) ami06N w=9e-07 l=6e-07 as=1.71e-12 ad=9.9e-13 \
        ps=4.5e-06 pd=2.1e-06 m=1 region=sat
    \+159 (44 137 129 44) ami06N w=9e-07 l=6e-07 as=1.71e-12 ad=9.9e-13 \
        ps=4.5e-06 pd=2.1e-06 m=1 region=sat
    \+158 (678 143 44 44) ami06N w=9e-07 l=6e-07 as=1.71e-12 ad=8.1e-13 \
        ps=4.5e-06 pd=1.8e-06 m=1 region=sat
    \+156 (122 138 113 44) ami06N w=9e-07 l=6e-07 as=1.54125e-12 \
        ad=1.71e-12 ps=3.15e-06 pd=4.5e-06 m=1 region=sat
    \+155 (123 139 114 44) ami06N w=9e-07 l=6e-07 as=1.54125e-12 \
        ad=1.71e-12 ps=3.15e-06 pd=4.5e-06 m=1 region=sat
    \+154 (124 140 115 44) ami06N w=9e-07 l=6e-07 as=1.54125e-12 \
        ad=1.71e-12 ps=3.15e-06 pd=4.5e-06 m=1 region=sat
    \+153 (125 141 116 44) ami06N w=9e-07 l=6e-07 as=1.54125e-12 \
        ad=1.71e-12 ps=3.15e-06 pd=4.5e-06 m=1 region=sat
    \+152 (126 142 117 44) ami06N w=9e-07 l=6e-07 as=1.54125e-12 \
        ad=1.71e-12 ps=3.15e-06 pd=4.5e-06 m=1 region=sat
    \+151 (127 143 118 44) ami06N w=9e-07 l=6e-07 as=1.54125e-12 \
        ad=1.71e-12 ps=3.15e-06 pd=4.5e-06 m=1 region=sat
    \+150 (120 44 111 44) ami06N w=9e-07 l=6e-07 as=1.54125e-12 \
        ad=1.71e-12 ps=3.15e-06 pd=4.5e-06 m=1 region=sat
    \+149 (121 137 112 44) ami06N w=9e-07 l=6e-07 as=1.54125e-12 \
        ad=1.71e-12 ps=3.15e-06 pd=4.5e-06 m=1 region=sat
    \+147 (124 225 667 44) ami06N w=9e-07 l=6e-07 as=9.9e-13 ad=1.71e-12 \
        ps=2.1e-06 pd=4.5e-06 m=1 region=sat
    \+146 (115 225 44 44) ami06N w=9e-07 l=6e-07 as=9.9e-13 ad=1.54125e-12 \
        ps=2.1e-06 pd=3.15e-06 m=1 region=sat
    \+145 (125 226 668 44) ami06N w=9e-07 l=6e-07 as=9.9e-13 ad=1.71e-12 \
        ps=2.1e-06 pd=4.5e-06 m=1 region=sat
    \+144 (120 221 663 44) ami06N w=9e-07 l=6e-07 as=9.9e-13 ad=1.71e-12 \
        ps=2.1e-06 pd=4.5e-06 m=1 region=sat
    \+143 (116 226 44 44) ami06N w=9e-07 l=6e-07 as=9.9e-13 ad=1.54125e-12 \
        ps=2.1e-06 pd=3.15e-06 m=1 region=sat
    \+142 (111 221 44 44) ami06N w=9e-07 l=6e-07 as=9.9e-13 ad=1.54125e-12 \
        ps=2.1e-06 pd=3.15e-06 m=1 region=sat
    \+141 (126 227 669 44) ami06N w=9e-07 l=6e-07 as=9.9e-13 ad=1.71e-12 \
        ps=2.1e-06 pd=4.5e-06 m=1 region=sat
    \+140 (121 222 664 44) ami06N w=9e-07 l=6e-07 as=9.9e-13 ad=1.71e-12 \
        ps=2.1e-06 pd=4.5e-06 m=1 region=sat
    \+139 (117 227 44 44) ami06N w=9e-07 l=6e-07 as=9.9e-13 ad=1.54125e-12 \
        ps=2.1e-06 pd=3.15e-06 m=1 region=sat
    \+138 (112 222 44 44) ami06N w=9e-07 l=6e-07 as=9.9e-13 ad=1.54125e-12 \
        ps=2.1e-06 pd=3.15e-06 m=1 region=sat
    \+137 (127 228 670 44) ami06N w=9e-07 l=6e-07 as=9.9e-13 ad=1.71e-12 \
        ps=2.1e-06 pd=4.5e-06 m=1 region=sat
    \+136 (122 223 665 44) ami06N w=9e-07 l=6e-07 as=9.9e-13 ad=1.71e-12 \
        ps=2.1e-06 pd=4.5e-06 m=1 region=sat
    \+135 (118 228 44 44) ami06N w=9e-07 l=6e-07 as=9.9e-13 ad=1.54125e-12 \
        ps=2.1e-06 pd=3.15e-06 m=1 region=sat
    \+134 (113 223 44 44) ami06N w=9e-07 l=6e-07 as=9.9e-13 ad=1.54125e-12 \
        ps=2.1e-06 pd=3.15e-06 m=1 region=sat
    \+133 (123 224 666 44) ami06N w=9e-07 l=6e-07 as=9.9e-13 ad=1.71e-12 \
        ps=2.1e-06 pd=4.5e-06 m=1 region=sat
    \+132 (114 224 44 44) ami06N w=9e-07 l=6e-07 as=9.9e-13 ad=1.54125e-12 \
        ps=2.1e-06 pd=3.15e-06 m=1 region=sat
    \+130 (44 241 112 44) ami06N w=9e-07 l=6e-07 as=1.71e-12 ad=9.9e-13 \
        ps=4.5e-06 pd=2.1e-06 m=1 region=sat
    \+129 (670 247 44 44) ami06N w=9e-07 l=6e-07 as=1.71e-12 ad=9.9e-13 \
        ps=4.5e-06 pd=2.1e-06 m=1 region=sat
    \+128 (665 242 44 44) ami06N w=9e-07 l=6e-07 as=1.71e-12 ad=9.9e-13 \
        ps=4.5e-06 pd=2.1e-06 m=1 region=sat
    \+127 (44 247 118 44) ami06N w=9e-07 l=6e-07 as=1.71e-12 ad=9.9e-13 \
        ps=4.5e-06 pd=2.1e-06 m=1 region=sat
    \+126 (44 242 113 44) ami06N w=9e-07 l=6e-07 as=1.71e-12 ad=9.9e-13 \
        ps=4.5e-06 pd=2.1e-06 m=1 region=sat
    \+125 (666 243 44 44) ami06N w=9e-07 l=6e-07 as=1.71e-12 ad=9.9e-13 \
        ps=4.5e-06 pd=2.1e-06 m=1 region=sat
    \+124 (44 243 114 44) ami06N w=9e-07 l=6e-07 as=1.71e-12 ad=9.9e-13 \
        ps=4.5e-06 pd=2.1e-06 m=1 region=sat
    \+123 (667 244 44 44) ami06N w=9e-07 l=6e-07 as=1.71e-12 ad=9.9e-13 \
        ps=4.5e-06 pd=2.1e-06 m=1 region=sat
    \+122 (44 244 115 44) ami06N w=9e-07 l=6e-07 as=1.71e-12 ad=9.9e-13 \
        ps=4.5e-06 pd=2.1e-06 m=1 region=sat
    \+121 (668 245 44 44) ami06N w=9e-07 l=6e-07 as=1.71e-12 ad=9.9e-13 \
        ps=4.5e-06 pd=2.1e-06 m=1 region=sat
    \+120 (663 240 44 44) ami06N w=9e-07 l=6e-07 as=1.71e-12 ad=9.9e-13 \
        ps=4.5e-06 pd=2.1e-06 m=1 region=sat
    \+119 (44 245 116 44) ami06N w=9e-07 l=6e-07 as=1.71e-12 ad=9.9e-13 \
        ps=4.5e-06 pd=2.1e-06 m=1 region=sat
    \+118 (44 240 111 44) ami06N w=9e-07 l=6e-07 as=1.71e-12 ad=9.9e-13 \
        ps=4.5e-06 pd=2.1e-06 m=1 region=sat
    \+117 (669 246 44 44) ami06N w=9e-07 l=6e-07 as=1.71e-12 ad=9.9e-13 \
        ps=4.5e-06 pd=2.1e-06 m=1 region=sat
    \+116 (664 241 44 44) ami06N w=9e-07 l=6e-07 as=1.71e-12 ad=9.9e-13 \
        ps=4.5e-06 pd=2.1e-06 m=1 region=sat
    \+115 (44 246 117 44) ami06N w=9e-07 l=6e-07 as=1.71e-12 ad=9.9e-13 \
        ps=4.5e-06 pd=2.1e-06 m=1 region=sat
    \+111 (51 96 44 44) ami06N w=9e-07 l=6e-07 as=1.71e-12 ad=1.71e-12 \
        ps=4.5e-06 pd=4.5e-06 m=1 region=sat
    \+110 (53 97 44 44) ami06N w=9e-07 l=6e-07 as=1.71e-12 ad=1.71e-12 \
        ps=4.5e-06 pd=4.5e-06 m=1 region=sat
    \+109 (55 98 44 44) ami06N w=9e-07 l=6e-07 as=1.71e-12 ad=1.71e-12 \
        ps=4.5e-06 pd=4.5e-06 m=1 region=sat
    \+108 (57 99 44 44) ami06N w=9e-07 l=6e-07 as=1.71e-12 ad=1.71e-12 \
        ps=4.5e-06 pd=4.5e-06 m=1 region=sat
    \+107 (59 100 44 44) ami06N w=9e-07 l=6e-07 as=1.71e-12 ad=1.71e-12 \
        ps=4.5e-06 pd=4.5e-06 m=1 region=sat
    \+106 (45 93 44 44) ami06N w=9e-07 l=6e-07 as=1.71e-12 ad=1.71e-12 \
        ps=4.5e-06 pd=4.5e-06 m=1 region=sat
    \+105 (47 94 44 44) ami06N w=9e-07 l=6e-07 as=1.71e-12 ad=1.71e-12 \
        ps=4.5e-06 pd=4.5e-06 m=1 region=sat
    \+104 (49 95 44 44) ami06N w=9e-07 l=6e-07 as=1.71e-12 ad=1.71e-12 \
        ps=4.5e-06 pd=4.5e-06 m=1 region=sat
    \+103 (44 45 101 44) ami06N w=9e-07 l=6e-07 as=1.71e-12 ad=1.71e-12 \
        ps=4.5e-06 pd=4.5e-06 m=1 region=sat
    \+102 (44 47 102 44) ami06N w=9e-07 l=6e-07 as=1.71e-12 ad=1.71e-12 \
        ps=4.5e-06 pd=4.5e-06 m=1 region=sat
    \+101 (44 49 103 44) ami06N w=9e-07 l=6e-07 as=1.71e-12 ad=1.71e-12 \
        ps=4.5e-06 pd=4.5e-06 m=1 region=sat
    \+100 (44 51 104 44) ami06N w=9e-07 l=6e-07 as=1.71e-12 ad=1.71e-12 \
        ps=4.5e-06 pd=4.5e-06 m=1 region=sat
    \+99 (44 53 105 44) ami06N w=9e-07 l=6e-07 as=1.71e-12 ad=1.71e-12 \
        ps=4.5e-06 pd=4.5e-06 m=1 region=sat
    \+98 (44 55 106 44) ami06N w=9e-07 l=6e-07 as=1.71e-12 ad=1.71e-12 \
        ps=4.5e-06 pd=4.5e-06 m=1 region=sat
    \+97 (44 57 107 44) ami06N w=9e-07 l=6e-07 as=1.71e-12 ad=1.71e-12 \
        ps=4.5e-06 pd=4.5e-06 m=1 region=sat
    \+96 (44 59 108 44) ami06N w=9e-07 l=6e-07 as=1.71e-12 ad=1.71e-12 \
        ps=4.5e-06 pd=4.5e-06 m=1 region=sat
    \+95 (101 F1 93 44) ami06N w=9e-07 l=6e-07 as=1.71e-12 ad=1.71e-12 \
        ps=4.5e-06 pd=4.5e-06 m=1 region=sat
    \+94 (102 F1 94 44) ami06N w=9e-07 l=6e-07 as=1.71e-12 ad=1.71e-12 \
        ps=4.5e-06 pd=4.5e-06 m=1 region=sat
    \+93 (103 F1 95 44) ami06N w=9e-07 l=6e-07 as=1.71e-12 ad=1.71e-12 \
        ps=4.5e-06 pd=4.5e-06 m=1 region=sat
    \+92 (104 F1 96 44) ami06N w=9e-07 l=6e-07 as=1.71e-12 ad=1.71e-12 \
        ps=4.5e-06 pd=4.5e-06 m=1 region=sat
    \+91 (105 F1 97 44) ami06N w=9e-07 l=6e-07 as=1.71e-12 ad=1.71e-12 \
        ps=4.5e-06 pd=4.5e-06 m=1 region=sat
    \+90 (106 F1 98 44) ami06N w=9e-07 l=6e-07 as=1.71e-12 ad=1.71e-12 \
        ps=4.5e-06 pd=4.5e-06 m=1 region=sat
    \+89 (107 F1 99 44) ami06N w=9e-07 l=6e-07 as=1.71e-12 ad=1.71e-12 \
        ps=4.5e-06 pd=4.5e-06 m=1 region=sat
    \+88 (108 F1 100 44) ami06N w=9e-07 l=6e-07 as=1.71e-12 ad=1.71e-12 \
        ps=4.5e-06 pd=4.5e-06 m=1 region=sat
    \+87 (98 F2 90 44) ami06N w=9e-07 l=6e-07 as=1.71e-12 ad=1.71e-12 \
        ps=4.5e-06 pd=4.5e-06 m=1 region=sat
    \+86 (99 F2 91 44) ami06N w=9e-07 l=6e-07 as=1.71e-12 ad=1.71e-12 \
        ps=4.5e-06 pd=4.5e-06 m=1 region=sat
    \+85 (100 F2 92 44) ami06N w=9e-07 l=6e-07 as=1.71e-12 ad=1.71e-12 \
        ps=4.5e-06 pd=4.5e-06 m=1 region=sat
    \+84 (93 F2 85 44) ami06N w=9e-07 l=6e-07 as=1.71e-12 ad=1.71e-12 \
        ps=4.5e-06 pd=4.5e-06 m=1 region=sat
    \+83 (94 F2 86 44) ami06N w=9e-07 l=6e-07 as=1.71e-12 ad=1.71e-12 \
        ps=4.5e-06 pd=4.5e-06 m=1 region=sat
    \+82 (95 F2 87 44) ami06N w=9e-07 l=6e-07 as=1.71e-12 ad=1.71e-12 \
        ps=4.5e-06 pd=4.5e-06 m=1 region=sat
    \+81 (96 F2 88 44) ami06N w=9e-07 l=6e-07 as=1.71e-12 ad=1.71e-12 \
        ps=4.5e-06 pd=4.5e-06 m=1 region=sat
    \+80 (97 F2 89 44) ami06N w=9e-07 l=6e-07 as=1.71e-12 ad=1.71e-12 \
        ps=4.5e-06 pd=4.5e-06 m=1 region=sat
    \+79 (87 74 44 44) ami06N w=9e-07 l=6e-07 as=1.71e-12 ad=1.71e-12 \
        ps=4.5e-06 pd=4.5e-06 m=1 region=sat
    \+78 (88 76 44 44) ami06N w=9e-07 l=6e-07 as=1.71e-12 ad=1.71e-12 \
        ps=4.5e-06 pd=4.5e-06 m=1 region=sat
    \+77 (89 78 44 44) ami06N w=9e-07 l=6e-07 as=1.71e-12 ad=1.71e-12 \
        ps=4.5e-06 pd=4.5e-06 m=1 region=sat
    \+76 (90 80 44 44) ami06N w=9e-07 l=6e-07 as=1.71e-12 ad=1.71e-12 \
        ps=4.5e-06 pd=4.5e-06 m=1 region=sat
    \+75 (91 82 44 44) ami06N w=9e-07 l=6e-07 as=1.71e-12 ad=1.71e-12 \
        ps=4.5e-06 pd=4.5e-06 m=1 region=sat
    \+74 (92 84 44 44) ami06N w=9e-07 l=6e-07 as=1.71e-12 ad=1.71e-12 \
        ps=4.5e-06 pd=4.5e-06 m=1 region=sat
    \+73 (85 70 44 44) ami06N w=9e-07 l=6e-07 as=1.71e-12 ad=1.71e-12 \
        ps=4.5e-06 pd=4.5e-06 m=1 region=sat
    \+72 (86 72 44 44) ami06N w=9e-07 l=6e-07 as=1.71e-12 ad=1.71e-12 \
        ps=4.5e-06 pd=4.5e-06 m=1 region=sat
    \+71 (44 85 69 44) ami06N w=9e-07 l=6e-07 as=1.71e-12 ad=1.71e-12 \
        ps=4.5e-06 pd=4.5e-06 m=1 region=sat
    \+70 (44 86 71 44) ami06N w=9e-07 l=6e-07 as=1.71e-12 ad=1.71e-12 \
        ps=4.5e-06 pd=4.5e-06 m=1 region=sat
    \+69 (44 87 73 44) ami06N w=9e-07 l=6e-07 as=1.71e-12 ad=1.71e-12 \
        ps=4.5e-06 pd=4.5e-06 m=1 region=sat
    \+68 (44 88 75 44) ami06N w=9e-07 l=6e-07 as=1.71e-12 ad=1.71e-12 \
        ps=4.5e-06 pd=4.5e-06 m=1 region=sat
    \+67 (44 89 77 44) ami06N w=9e-07 l=6e-07 as=1.71e-12 ad=1.71e-12 \
        ps=4.5e-06 pd=4.5e-06 m=1 region=sat
    \+66 (44 90 79 44) ami06N w=9e-07 l=6e-07 as=1.71e-12 ad=1.71e-12 \
        ps=4.5e-06 pd=4.5e-06 m=1 region=sat
    \+65 (44 91 81 44) ami06N w=9e-07 l=6e-07 as=1.71e-12 ad=1.71e-12 \
        ps=4.5e-06 pd=4.5e-06 m=1 region=sat
    \+64 (44 92 83 44) ami06N w=9e-07 l=6e-07 as=1.71e-12 ad=1.71e-12 \
        ps=4.5e-06 pd=4.5e-06 m=1 region=sat
    \+47 (63 Input_S0 645 44) ami06N w=9e-07 l=6e-07 as=9.9e-13 \
        ad=1.71e-12 ps=2.1e-06 pd=4.5e-06 m=1 region=sat
    \+46 (66 Input_S0 656 44) ami06N w=9e-07 l=6e-07 as=9.9e-13 \
        ad=1.71e-12 ps=2.1e-06 pd=4.5e-06 m=1 region=sat
    \+45 (63 Input_S0B 646 44) ami06N w=9e-07 l=6e-07 as=9.9e-13 \
        ad=1.71e-12 ps=2.1e-06 pd=4.5e-06 m=1 region=sat
    \+44 (67 Input_S0 657 44) ami06N w=9e-07 l=6e-07 as=9.9e-13 \
        ad=1.71e-12 ps=2.1e-06 pd=4.5e-06 m=1 region=sat
    \+43 (63 Input_S0 647 44) ami06N w=9e-07 l=6e-07 as=9.9e-13 \
        ad=1.71e-12 ps=2.1e-06 pd=4.5e-06 m=1 region=sat
    \+42 (67 Input_S0B 658 44) ami06N w=9e-07 l=6e-07 as=9.9e-13 \
        ad=1.71e-12 ps=2.1e-06 pd=4.5e-06 m=1 region=sat
    \+41 (64 Input_S0 648 44) ami06N w=9e-07 l=6e-07 as=9.9e-13 \
        ad=1.71e-12 ps=2.1e-06 pd=4.5e-06 m=1 region=sat
    \+40 (67 Input_S0 659 44) ami06N w=9e-07 l=6e-07 as=9.9e-13 \
        ad=1.71e-12 ps=2.1e-06 pd=4.5e-06 m=1 region=sat
    \+39 (64 Input_S0B 649 44) ami06N w=9e-07 l=6e-07 as=9.9e-13 \
        ad=1.71e-12 ps=2.1e-06 pd=4.5e-06 m=1 region=sat
    \+38 (68 Input_S0 660 44) ami06N w=9e-07 l=6e-07 as=9.9e-13 \
        ad=1.71e-12 ps=2.1e-06 pd=4.5e-06 m=1 region=sat
    \+37 (61 Input_S0 639 44) ami06N w=9e-07 l=6e-07 as=9.9e-13 \
        ad=1.71e-12 ps=2.1e-06 pd=4.5e-06 m=1 region=sat
    \+36 (64 Input_S0 650 44) ami06N w=9e-07 l=6e-07 as=9.9e-13 \
        ad=1.71e-12 ps=2.1e-06 pd=4.5e-06 m=1 region=sat
    \+35 (68 Input_S0B 661 44) ami06N w=9e-07 l=6e-07 as=9.9e-13 \
        ad=1.71e-12 ps=2.1e-06 pd=4.5e-06 m=1 region=sat
    \+34 (61 Input_S0B 640 44) ami06N w=9e-07 l=6e-07 as=9.9e-13 \
        ad=1.71e-12 ps=2.1e-06 pd=4.5e-06 m=1 region=sat
    \+33 (65 Input_S0 651 44) ami06N w=9e-07 l=6e-07 as=9.9e-13 \
        ad=1.71e-12 ps=2.1e-06 pd=4.5e-06 m=1 region=sat
    \+32 (68 Input_S0 662 44) ami06N w=9e-07 l=6e-07 as=9.9e-13 \
        ad=1.71e-12 ps=2.1e-06 pd=4.5e-06 m=1 region=sat
    \+31 (61 Input_S0 641 44) ami06N w=9e-07 l=6e-07 as=9.9e-13 \
        ad=1.71e-12 ps=2.1e-06 pd=4.5e-06 m=1 region=sat
    \+30 (65 Input_S0B 652 44) ami06N w=9e-07 l=6e-07 as=9.9e-13 \
        ad=1.71e-12 ps=2.1e-06 pd=4.5e-06 m=1 region=sat
    \+29 (62 Input_S0 642 44) ami06N w=9e-07 l=6e-07 as=9.9e-13 \
        ad=1.71e-12 ps=2.1e-06 pd=4.5e-06 m=1 region=sat
    \+28 (65 Input_S0 653 44) ami06N w=9e-07 l=6e-07 as=9.9e-13 \
        ad=1.71e-12 ps=2.1e-06 pd=4.5e-06 m=1 region=sat
    \+27 (62 Input_S0B 643 44) ami06N w=9e-07 l=6e-07 as=9.9e-13 \
        ad=1.71e-12 ps=2.1e-06 pd=4.5e-06 m=1 region=sat
    \+26 (66 Input_S0 654 44) ami06N w=9e-07 l=6e-07 as=9.9e-13 \
        ad=1.71e-12 ps=2.1e-06 pd=4.5e-06 m=1 region=sat
    \+25 (62 Input_S0 644 44) ami06N w=9e-07 l=6e-07 as=9.9e-13 \
        ad=1.71e-12 ps=2.1e-06 pd=4.5e-06 m=1 region=sat
    \+24 (66 Input_S0B 655 44) ami06N w=9e-07 l=6e-07 as=9.9e-13 \
        ad=1.71e-12 ps=2.1e-06 pd=4.5e-06 m=1 region=sat
    \+23 (647 Input_S1B 44 44) ami06N w=9e-07 l=6e-07 as=1.71e-12 \
        ad=9.9e-13 ps=4.5e-06 pd=2.1e-06 m=1 region=sat
    \+22 (658 Input_S1 58 44) ami06N w=9e-07 l=6e-07 as=1.71e-12 \
        ad=9.9e-13 ps=4.5e-06 pd=2.1e-06 m=1 region=sat
    \+21 (648 Input_S1 51 44) ami06N w=9e-07 l=6e-07 as=1.71e-12 \
        ad=9.9e-13 ps=4.5e-06 pd=2.1e-06 m=1 region=sat
    \+20 (659 Input_S1B 44 44) ami06N w=9e-07 l=6e-07 as=1.71e-12 \
        ad=9.9e-13 ps=4.5e-06 pd=2.1e-06 m=1 region=sat
    \+19 (649 Input_S1 52 44) ami06N w=9e-07 l=6e-07 as=1.71e-12 \
        ad=9.9e-13 ps=4.5e-06 pd=2.1e-06 m=1 region=sat
    \+18 (660 Input_S1 59 44) ami06N w=9e-07 l=6e-07 as=1.71e-12 \
        ad=9.9e-13 ps=4.5e-06 pd=2.1e-06 m=1 region=sat
    \+17 (639 Input_S1 45 44) ami06N w=9e-07 l=6e-07 as=1.71e-12 \
        ad=9.9e-13 ps=4.5e-06 pd=2.1e-06 m=1 region=sat
    \+16 (650 Input_S1B 44 44) ami06N w=9e-07 l=6e-07 as=1.71e-12 \
        ad=9.9e-13 ps=4.5e-06 pd=2.1e-06 m=1 region=sat
    \+15 (661 Input_S1 60 44) ami06N w=9e-07 l=6e-07 as=1.71e-12 \
        ad=9.9e-13 ps=4.5e-06 pd=2.1e-06 m=1 region=sat
    \+14 (640 Input_S1 46 44) ami06N w=9e-07 l=6e-07 as=1.71e-12 \
        ad=9.9e-13 ps=4.5e-06 pd=2.1e-06 m=1 region=sat
    \+13 (651 Input_S1 53 44) ami06N w=9e-07 l=6e-07 as=1.71e-12 \
        ad=9.9e-13 ps=4.5e-06 pd=2.1e-06 m=1 region=sat
    \+12 (662 Input_S1B 44 44) ami06N w=9e-07 l=6e-07 as=1.71e-12 \
        ad=9.9e-13 ps=4.5e-06 pd=2.1e-06 m=1 region=sat
    \+11 (641 Input_S1B 44 44) ami06N w=9e-07 l=6e-07 as=1.71e-12 \
        ad=9.9e-13 ps=4.5e-06 pd=2.1e-06 m=1 region=sat
    \+10 (652 Input_S1 54 44) ami06N w=9e-07 l=6e-07 as=1.71e-12 \
        ad=9.9e-13 ps=4.5e-06 pd=2.1e-06 m=1 region=sat
    \+9 (642 Input_S1 47 44) ami06N w=9e-07 l=6e-07 as=1.71e-12 ad=9.9e-13 \
        ps=4.5e-06 pd=2.1e-06 m=1 region=sat
    \+8 (653 Input_S1B 44 44) ami06N w=9e-07 l=6e-07 as=1.71e-12 \
        ad=9.9e-13 ps=4.5e-06 pd=2.1e-06 m=1 region=sat
    \+7 (643 Input_S1 48 44) ami06N w=9e-07 l=6e-07 as=1.71e-12 ad=9.9e-13 \
        ps=4.5e-06 pd=2.1e-06 m=1 region=sat
    \+6 (654 Input_S1 55 44) ami06N w=9e-07 l=6e-07 as=1.71e-12 ad=9.9e-13 \
        ps=4.5e-06 pd=2.1e-06 m=1 region=sat
    \+5 (644 Input_S1B 44 44) ami06N w=9e-07 l=6e-07 as=1.71e-12 \
        ad=9.9e-13 ps=4.5e-06 pd=2.1e-06 m=1 region=sat
    \+4 (655 Input_S1 56 44) ami06N w=9e-07 l=6e-07 as=1.71e-12 ad=9.9e-13 \
        ps=4.5e-06 pd=2.1e-06 m=1 region=sat
    \+3 (645 Input_S1 49 44) ami06N w=9e-07 l=6e-07 as=1.71e-12 ad=9.9e-13 \
        ps=4.5e-06 pd=2.1e-06 m=1 region=sat
    \+2 (656 Input_S1B 44 44) ami06N w=9e-07 l=6e-07 as=1.71e-12 \
        ad=9.9e-13 ps=4.5e-06 pd=2.1e-06 m=1 region=sat
    \+1 (646 Input_S1 50 44) ami06N w=9e-07 l=6e-07 as=1.71e-12 ad=9.9e-13 \
        ps=4.5e-06 pd=2.1e-06 m=1 region=sat
    \+0 (657 Input_S1 57 44) ami06N w=9e-07 l=6e-07 as=1.71e-12 ad=9.9e-13 \
        ps=4.5e-06 pd=2.1e-06 m=1 region=sat
    \+1267 (1015 560 44 44) ami06N w=9e-07 l=6e-07 as=1.71e-12 \
        ad=1.45125e-12 ps=4.5e-06 pd=3e-06 m=1 region=sat
    \+1266 (382 561 1015 44) ami06N w=9e-07 l=6e-07 as=1.45125e-12 \
        ad=1.71e-12 ps=3e-06 pd=4.5e-06 m=1 region=sat
    \+1265 (1016 562 44 44) ami06N w=9e-07 l=6e-07 as=1.71e-12 \
        ad=1.45125e-12 ps=4.5e-06 pd=3e-06 m=1 region=sat
    \+1264 (384 563 1016 44) ami06N w=9e-07 l=6e-07 as=1.45125e-12 \
        ad=1.71e-12 ps=3e-06 pd=4.5e-06 m=1 region=sat
    \+1263 (1017 564 44 44) ami06N w=9e-07 l=6e-07 as=1.71e-12 \
        ad=1.45125e-12 ps=4.5e-06 pd=3e-06 m=1 region=sat
    \+1262 (386 565 1017 44) ami06N w=9e-07 l=6e-07 as=1.45125e-12 \
        ad=1.71e-12 ps=3e-06 pd=4.5e-06 m=1 region=sat
    \+1261 (1018 566 44 44) ami06N w=9e-07 l=6e-07 as=1.71e-12 \
        ad=1.45125e-12 ps=4.5e-06 pd=3e-06 m=1 region=sat
    \+1260 (388 567 1018 44) ami06N w=9e-07 l=6e-07 as=1.45125e-12 \
        ad=1.71e-12 ps=3e-06 pd=4.5e-06 m=1 region=sat
    \+1259 (1019 568 44 44) ami06N w=9e-07 l=6e-07 as=1.71e-12 \
        ad=1.45125e-12 ps=4.5e-06 pd=3e-06 m=1 region=sat
    \+1258 (390 569 1019 44) ami06N w=9e-07 l=6e-07 as=1.45125e-12 \
        ad=1.71e-12 ps=3e-06 pd=4.5e-06 m=1 region=sat
    \+1249 (1010 vdd! 44 44) ami06N w=9e-07 l=6e-07 as=1.71e-12 \
        ad=1.53e-12 ps=4.5e-06 pd=3.15e-06 m=1 region=sat
    \+1248 (382 381 1010 44) ami06N w=9e-07 l=6e-07 as=1.53e-12 \
        ad=1.71e-12 ps=3.15e-06 pd=4.5e-06 m=1 region=sat
    \+1247 (1011 594 44 44) ami06N w=9e-07 l=6e-07 as=1.71e-12 ad=1.53e-12 \
        ps=4.5e-06 pd=3.15e-06 m=1 region=sat
    \+1246 (384 383 1011 44) ami06N w=9e-07 l=6e-07 as=1.53e-12 \
        ad=1.71e-12 ps=3.15e-06 pd=4.5e-06 m=1 region=sat
    \+1245 (1012 595 44 44) ami06N w=9e-07 l=6e-07 as=1.71e-12 ad=1.53e-12 \
        ps=4.5e-06 pd=3.15e-06 m=1 region=sat
    \+1244 (386 385 1012 44) ami06N w=9e-07 l=6e-07 as=1.53e-12 \
        ad=1.71e-12 ps=3.15e-06 pd=4.5e-06 m=1 region=sat
    \+1243 (1013 596 44 44) ami06N w=9e-07 l=6e-07 as=1.71e-12 ad=1.53e-12 \
        ps=4.5e-06 pd=3.15e-06 m=1 region=sat
    \+1242 (388 387 1013 44) ami06N w=9e-07 l=6e-07 as=1.53e-12 \
        ad=1.71e-12 ps=3.15e-06 pd=4.5e-06 m=1 region=sat
    \+1241 (1014 597 44 44) ami06N w=9e-07 l=6e-07 as=1.71e-12 ad=1.53e-12 \
        ps=4.5e-06 pd=3.15e-06 m=1 region=sat
    \+1240 (390 389 1014 44) ami06N w=9e-07 l=6e-07 as=1.53e-12 \
        ad=1.71e-12 ps=3.15e-06 pd=4.5e-06 m=1 region=sat
    \+1057 (445 F2 444 44) ami06N w=9e-07 l=6e-07 as=1.71e-12 ad=1.71e-12 \
        ps=4.5e-06 pd=4.5e-06 m=1 region=sat
    \+1056 (422 F1 467 44) ami06N w=9e-07 l=6e-07 as=1.71e-12 ad=1.71e-12 \
        ps=4.5e-06 pd=4.5e-06 m=1 region=sat
    \+1055 (411 F1 445 44) ami06N w=9e-07 l=6e-07 as=1.71e-12 ad=1.71e-12 \
        ps=4.5e-06 pd=4.5e-06 m=1 region=sat
    \+1054 (469 F2 468 44) ami06N w=9e-07 l=6e-07 as=1.71e-12 ad=1.71e-12 \
        ps=4.5e-06 pd=4.5e-06 m=1 region=sat
    \+1053 (447 F2 446 44) ami06N w=9e-07 l=6e-07 as=1.71e-12 ad=1.71e-12 \
        ps=4.5e-06 pd=4.5e-06 m=1 region=sat
    \+1052 (423 F1 469 44) ami06N w=9e-07 l=6e-07 as=1.71e-12 ad=1.71e-12 \
        ps=4.5e-06 pd=4.5e-06 m=1 region=sat
    \+1051 (412 F1 447 44) ami06N w=9e-07 l=6e-07 as=1.71e-12 ad=1.71e-12 \
        ps=4.5e-06 pd=4.5e-06 m=1 region=sat
    \+1050 (471 F2 470 44) ami06N w=9e-07 l=6e-07 as=1.71e-12 ad=1.71e-12 \
        ps=4.5e-06 pd=4.5e-06 m=1 region=sat
    \+1049 (449 F2 448 44) ami06N w=9e-07 l=6e-07 as=1.71e-12 ad=1.71e-12 \
        ps=4.5e-06 pd=4.5e-06 m=1 region=sat
    \+1048 (424 F1 471 44) ami06N w=9e-07 l=6e-07 as=1.71e-12 ad=1.71e-12 \
        ps=4.5e-06 pd=4.5e-06 m=1 region=sat
    \+1047 (413 F1 449 44) ami06N w=9e-07 l=6e-07 as=1.71e-12 ad=1.71e-12 \
        ps=4.5e-06 pd=4.5e-06 m=1 region=sat
    \+1046 (473 F2 472 44) ami06N w=9e-07 l=6e-07 as=1.71e-12 ad=1.71e-12 \
        ps=4.5e-06 pd=4.5e-06 m=1 region=sat
    \+1045 (451 F2 450 44) ami06N w=9e-07 l=6e-07 as=1.71e-12 ad=1.71e-12 \
        ps=4.5e-06 pd=4.5e-06 m=1 region=sat
    \+1044 (425 F1 473 44) ami06N w=9e-07 l=6e-07 as=1.71e-12 ad=1.71e-12 \
        ps=4.5e-06 pd=4.5e-06 m=1 region=sat
    \+1043 (414 F1 451 44) ami06N w=9e-07 l=6e-07 as=1.71e-12 ad=1.71e-12 \
        ps=4.5e-06 pd=4.5e-06 m=1 region=sat
    \+1042 (475 F2 474 44) ami06N w=9e-07 l=6e-07 as=1.71e-12 ad=1.71e-12 \
        ps=4.5e-06 pd=4.5e-06 m=1 region=sat
    \+1041 (453 F2 452 44) ami06N w=9e-07 l=6e-07 as=1.71e-12 ad=1.71e-12 \
        ps=4.5e-06 pd=4.5e-06 m=1 region=sat
    \+1040 (426 F1 475 44) ami06N w=9e-07 l=6e-07 as=1.71e-12 ad=1.71e-12 \
        ps=4.5e-06 pd=4.5e-06 m=1 region=sat
    \+1039 (431 F2 430 44) ami06N w=9e-07 l=6e-07 as=1.71e-12 ad=1.71e-12 \
        ps=4.5e-06 pd=4.5e-06 m=1 region=sat
    \+1038 (415 F1 453 44) ami06N w=9e-07 l=6e-07 as=1.71e-12 ad=1.71e-12 \
        ps=4.5e-06 pd=4.5e-06 m=1 region=sat
    \+1037 (477 F2 476 44) ami06N w=9e-07 l=6e-07 as=1.71e-12 ad=1.71e-12 \
        ps=4.5e-06 pd=4.5e-06 m=1 region=sat
    \+1036 (404 F1 431 44) ami06N w=9e-07 l=6e-07 as=1.71e-12 ad=1.71e-12 \
        ps=4.5e-06 pd=4.5e-06 m=1 region=sat
    \+1035 (455 F2 454 44) ami06N w=9e-07 l=6e-07 as=1.71e-12 ad=1.71e-12 \
        ps=4.5e-06 pd=4.5e-06 m=1 region=sat
    \+1034 (427 F1 477 44) ami06N w=9e-07 l=6e-07 as=1.71e-12 ad=1.71e-12 \
        ps=4.5e-06 pd=4.5e-06 m=1 region=sat
    \+1033 (433 F2 432 44) ami06N w=9e-07 l=6e-07 as=1.71e-12 ad=1.71e-12 \
        ps=4.5e-06 pd=4.5e-06 m=1 region=sat
    \+1032 (416 F1 455 44) ami06N w=9e-07 l=6e-07 as=1.71e-12 ad=1.71e-12 \
        ps=4.5e-06 pd=4.5e-06 m=1 region=sat
    \+1031 (479 F2 478 44) ami06N w=9e-07 l=6e-07 as=1.71e-12 ad=1.71e-12 \
        ps=4.5e-06 pd=4.5e-06 m=1 region=sat
    \+1030 (405 F1 433 44) ami06N w=9e-07 l=6e-07 as=1.71e-12 ad=1.71e-12 \
        ps=4.5e-06 pd=4.5e-06 m=1 region=sat
    \+1029 (457 F2 456 44) ami06N w=9e-07 l=6e-07 as=1.71e-12 ad=1.71e-12 \
        ps=4.5e-06 pd=4.5e-06 m=1 region=sat
    \+1028 (428 F1 479 44) ami06N w=9e-07 l=6e-07 as=1.71e-12 ad=1.71e-12 \
        ps=4.5e-06 pd=4.5e-06 m=1 region=sat
    \+1027 (435 F2 434 44) ami06N w=9e-07 l=6e-07 as=1.71e-12 ad=1.71e-12 \
        ps=4.5e-06 pd=4.5e-06 m=1 region=sat
    \+1026 (417 F1 457 44) ami06N w=9e-07 l=6e-07 as=1.71e-12 ad=1.71e-12 \
        ps=4.5e-06 pd=4.5e-06 m=1 region=sat
    \+1025 (481 F2 480 44) ami06N w=9e-07 l=6e-07 as=1.71e-12 ad=1.71e-12 \
        ps=4.5e-06 pd=4.5e-06 m=1 region=sat
    \+1024 (406 F1 435 44) ami06N w=9e-07 l=6e-07 as=1.71e-12 ad=1.71e-12 \
        ps=4.5e-06 pd=4.5e-06 m=1 region=sat
    \+1023 (459 F2 458 44) ami06N w=9e-07 l=6e-07 as=1.71e-12 ad=1.71e-12 \
        ps=4.5e-06 pd=4.5e-06 m=1 region=sat
    \+1022 (429 F1 481 44) ami06N w=9e-07 l=6e-07 as=1.71e-12 ad=1.71e-12 \
        ps=4.5e-06 pd=4.5e-06 m=1 region=sat
    \+1021 (437 F2 436 44) ami06N w=9e-07 l=6e-07 as=1.71e-12 ad=1.71e-12 \
        ps=4.5e-06 pd=4.5e-06 m=1 region=sat
    \+1020 (418 F1 459 44) ami06N w=9e-07 l=6e-07 as=1.71e-12 ad=1.71e-12 \
        ps=4.5e-06 pd=4.5e-06 m=1 region=sat
    \+1019 (407 F1 437 44) ami06N w=9e-07 l=6e-07 as=1.71e-12 ad=1.71e-12 \
        ps=4.5e-06 pd=4.5e-06 m=1 region=sat
    \+1018 (461 F2 460 44) ami06N w=9e-07 l=6e-07 as=1.71e-12 ad=1.71e-12 \
        ps=4.5e-06 pd=4.5e-06 m=1 region=sat
    \+1017 (439 F2 438 44) ami06N w=9e-07 l=6e-07 as=1.71e-12 ad=1.71e-12 \
        ps=4.5e-06 pd=4.5e-06 m=1 region=sat
    \+1016 (419 F1 461 44) ami06N w=9e-07 l=6e-07 as=1.71e-12 ad=1.71e-12 \
        ps=4.5e-06 pd=4.5e-06 m=1 region=sat
    \+1015 (408 F1 439 44) ami06N w=9e-07 l=6e-07 as=1.71e-12 ad=1.71e-12 \
        ps=4.5e-06 pd=4.5e-06 m=1 region=sat
    \+1014 (463 F2 462 44) ami06N w=9e-07 l=6e-07 as=1.71e-12 ad=1.71e-12 \
        ps=4.5e-06 pd=4.5e-06 m=1 region=sat
    \+1013 (441 F2 440 44) ami06N w=9e-07 l=6e-07 as=1.71e-12 ad=1.71e-12 \
        ps=4.5e-06 pd=4.5e-06 m=1 region=sat
    \+1012 (420 F1 463 44) ami06N w=9e-07 l=6e-07 as=1.71e-12 ad=1.71e-12 \
        ps=4.5e-06 pd=4.5e-06 m=1 region=sat
    \+1011 (409 F1 441 44) ami06N w=9e-07 l=6e-07 as=1.71e-12 ad=1.71e-12 \
        ps=4.5e-06 pd=4.5e-06 m=1 region=sat
    \+1010 (465 F2 464 44) ami06N w=9e-07 l=6e-07 as=1.71e-12 ad=1.71e-12 \
        ps=4.5e-06 pd=4.5e-06 m=1 region=sat
    \+1009 (443 F2 442 44) ami06N w=9e-07 l=6e-07 as=1.71e-12 ad=1.71e-12 \
        ps=4.5e-06 pd=4.5e-06 m=1 region=sat
    \+1008 (421 F1 465 44) ami06N w=9e-07 l=6e-07 as=1.71e-12 ad=1.71e-12 \
        ps=4.5e-06 pd=4.5e-06 m=1 region=sat
    \+1007 (410 F1 443 44) ami06N w=9e-07 l=6e-07 as=1.71e-12 ad=1.71e-12 \
        ps=4.5e-06 pd=4.5e-06 m=1 region=sat
    \+1006 (467 F2 466 44) ami06N w=9e-07 l=6e-07 as=1.71e-12 ad=1.71e-12 \
        ps=4.5e-06 pd=4.5e-06 m=1 region=sat
    \+759 (44 Memory\<0\> 348 44) ami06N w=9e-07 l=6e-07 as=1.71e-12 \
        ad=1.71e-12 ps=4.5e-06 pd=4.5e-06 m=1 region=sat
    \+757 (334 F2 316 44) ami06N w=9e-07 l=6e-07 as=1.71e-12 ad=1.71e-12 \
        ps=4.5e-06 pd=4.5e-06 m=1 region=sat
    \+756 (335 F1 334 44) ami06N w=9e-07 l=6e-07 as=1.71e-12 ad=1.71e-12 \
        ps=4.5e-06 pd=4.5e-06 m=1 region=sat
    \+755 (336 F2 317 44) ami06N w=9e-07 l=6e-07 as=1.71e-12 ad=1.71e-12 \
        ps=4.5e-06 pd=4.5e-06 m=1 region=sat
    \+754 (337 F1 336 44) ami06N w=9e-07 l=6e-07 as=1.71e-12 ad=1.71e-12 \
        ps=4.5e-06 pd=4.5e-06 m=1 region=sat
    \+753 (338 F2 318 44) ami06N w=9e-07 l=6e-07 as=1.71e-12 ad=1.71e-12 \
        ps=4.5e-06 pd=4.5e-06 m=1 region=sat
    \+752 (339 F1 338 44) ami06N w=9e-07 l=6e-07 as=1.71e-12 ad=1.71e-12 \
        ps=4.5e-06 pd=4.5e-06 m=1 region=sat
    \+751 (340 F2 319 44) ami06N w=9e-07 l=6e-07 as=1.71e-12 ad=1.71e-12 \
        ps=4.5e-06 pd=4.5e-06 m=1 region=sat
    \+750 (341 F1 340 44) ami06N w=9e-07 l=6e-07 as=1.71e-12 ad=1.71e-12 \
        ps=4.5e-06 pd=4.5e-06 m=1 region=sat
    \+749 (342 F2 320 44) ami06N w=9e-07 l=6e-07 as=1.71e-12 ad=1.71e-12 \
        ps=4.5e-06 pd=4.5e-06 m=1 region=sat
    \+748 (343 F1 342 44) ami06N w=9e-07 l=6e-07 as=1.71e-12 ad=1.71e-12 \
        ps=4.5e-06 pd=4.5e-06 m=1 region=sat
    \+747 (344 F2 321 44) ami06N w=9e-07 l=6e-07 as=1.71e-12 ad=1.71e-12 \
        ps=4.5e-06 pd=4.5e-06 m=1 region=sat
    \+746 (345 F1 344 44) ami06N w=9e-07 l=6e-07 as=1.71e-12 ad=1.71e-12 \
        ps=4.5e-06 pd=4.5e-06 m=1 region=sat
    \+745 (346 F2 322 44) ami06N w=9e-07 l=6e-07 as=1.71e-12 ad=1.71e-12 \
        ps=4.5e-06 pd=4.5e-06 m=1 region=sat
    \+744 (347 F1 346 44) ami06N w=9e-07 l=6e-07 as=1.71e-12 ad=1.71e-12 \
        ps=4.5e-06 pd=4.5e-06 m=1 region=sat
    \+743 (332 F2 315 44) ami06N w=9e-07 l=6e-07 as=1.71e-12 ad=1.71e-12 \
        ps=4.5e-06 pd=4.5e-06 m=1 region=sat
    \+742 (333 F1 332 44) ami06N w=9e-07 l=6e-07 as=1.71e-12 ad=1.71e-12 \
        ps=4.5e-06 pd=4.5e-06 m=1 region=sat
    \+741 (44 348 331 44) ami06N w=9e-07 l=6e-07 as=1.71e-12 ad=1.71e-12 \
        ps=4.5e-06 pd=4.5e-06 m=1 region=sat
    \+660 (44 Memory\<1\> 282 44) ami06N w=9e-07 l=6e-07 as=1.71e-12 \
        ad=1.71e-12 ps=4.5e-06 pd=4.5e-06 m=1 region=sat
    \+643 (249 634 259 44) ami06N w=9e-07 l=6e-07 as=1.71e-12 ad=1.71e-12 \
        ps=4.5e-06 pd=4.5e-06 m=1 region=sat
    \+642 (261 633 260 44) ami06N w=9e-07 l=6e-07 as=1.71e-12 ad=1.71e-12 \
        ps=4.5e-06 pd=4.5e-06 m=1 region=sat
    \+641 (250 634 261 44) ami06N w=9e-07 l=6e-07 as=1.71e-12 ad=1.71e-12 \
        ps=4.5e-06 pd=4.5e-06 m=1 region=sat
    \+640 (263 633 262 44) ami06N w=9e-07 l=6e-07 as=1.71e-12 ad=1.71e-12 \
        ps=4.5e-06 pd=4.5e-06 m=1 region=sat
    \+639 (251 634 263 44) ami06N w=9e-07 l=6e-07 as=1.71e-12 ad=1.71e-12 \
        ps=4.5e-06 pd=4.5e-06 m=1 region=sat
    \+638 (265 633 264 44) ami06N w=9e-07 l=6e-07 as=1.71e-12 ad=1.71e-12 \
        ps=4.5e-06 pd=4.5e-06 m=1 region=sat
    \+637 (252 634 265 44) ami06N w=9e-07 l=6e-07 as=1.71e-12 ad=1.71e-12 \
        ps=4.5e-06 pd=4.5e-06 m=1 region=sat
    \+636 (267 633 266 44) ami06N w=9e-07 l=6e-07 as=1.71e-12 ad=1.71e-12 \
        ps=4.5e-06 pd=4.5e-06 m=1 region=sat
    \+635 (253 634 267 44) ami06N w=9e-07 l=6e-07 as=1.71e-12 ad=1.71e-12 \
        ps=4.5e-06 pd=4.5e-06 m=1 region=sat
    \+634 (269 633 268 44) ami06N w=9e-07 l=6e-07 as=1.71e-12 ad=1.71e-12 \
        ps=4.5e-06 pd=4.5e-06 m=1 region=sat
    \+633 (254 634 269 44) ami06N w=9e-07 l=6e-07 as=1.71e-12 ad=1.71e-12 \
        ps=4.5e-06 pd=4.5e-06 m=1 region=sat
    \+632 (271 633 270 44) ami06N w=9e-07 l=6e-07 as=1.71e-12 ad=1.71e-12 \
        ps=4.5e-06 pd=4.5e-06 m=1 region=sat
    \+631 (255 634 271 44) ami06N w=9e-07 l=6e-07 as=1.71e-12 ad=1.71e-12 \
        ps=4.5e-06 pd=4.5e-06 m=1 region=sat
    \+630 (273 633 272 44) ami06N w=9e-07 l=6e-07 as=1.71e-12 ad=1.71e-12 \
        ps=4.5e-06 pd=4.5e-06 m=1 region=sat
    \+629 (256 634 273 44) ami06N w=9e-07 l=6e-07 as=1.71e-12 ad=1.71e-12 \
        ps=4.5e-06 pd=4.5e-06 m=1 region=sat
    \+628 (259 633 258 44) ami06N w=9e-07 l=6e-07 as=1.71e-12 ad=1.71e-12 \
        ps=4.5e-06 pd=4.5e-06 m=1 region=sat
    \+626 (44 282 257 44) ami06N w=9e-07 l=6e-07 as=1.71e-12 ad=1.71e-12 \
        ps=4.5e-06 pd=4.5e-06 m=1 region=sat
    \+585 (44 Memory\<2\> 248 44) ami06N w=9e-07 l=6e-07 as=1.71e-12 \
        ad=1.71e-12 ps=4.5e-06 pd=4.5e-06 m=1 region=sat
    \+503 (44 248 239 44) ami06N w=9e-07 l=6e-07 as=1.71e-12 ad=1.71e-12 \
        ps=4.5e-06 pd=4.5e-06 m=1 region=sat
    \+502 (44 Memory\<3\> 238 44) ami06N w=9e-07 l=6e-07 as=1.71e-12 \
        ad=1.71e-12 ps=4.5e-06 pd=4.5e-06 m=1 region=sat
    \+388 (44 238 229 44) ami06N w=9e-07 l=6e-07 as=1.71e-12 ad=1.71e-12 \
        ps=4.5e-06 pd=4.5e-06 m=1 region=sat
    \+331 (44 224 216 44) ami06N w=9e-07 l=6e-07 as=1.71e-12 ad=1.71e-12 \
        ps=4.5e-06 pd=4.5e-06 m=1 region=sat
    \+330 (44 225 217 44) ami06N w=9e-07 l=6e-07 as=1.71e-12 ad=1.71e-12 \
        ps=4.5e-06 pd=4.5e-06 m=1 region=sat
    \+329 (44 226 218 44) ami06N w=9e-07 l=6e-07 as=1.71e-12 ad=1.71e-12 \
        ps=4.5e-06 pd=4.5e-06 m=1 region=sat
    \+328 (44 227 219 44) ami06N w=9e-07 l=6e-07 as=1.71e-12 ad=1.71e-12 \
        ps=4.5e-06 pd=4.5e-06 m=1 region=sat
    \+327 (44 228 220 44) ami06N w=9e-07 l=6e-07 as=1.71e-12 ad=1.71e-12 \
        ps=4.5e-06 pd=4.5e-06 m=1 region=sat
    \+326 (44 221 213 44) ami06N w=9e-07 l=6e-07 as=1.71e-12 ad=1.71e-12 \
        ps=4.5e-06 pd=4.5e-06 m=1 region=sat
    \+325 (44 222 214 44) ami06N w=9e-07 l=6e-07 as=1.71e-12 ad=1.71e-12 \
        ps=4.5e-06 pd=4.5e-06 m=1 region=sat
    \+324 (44 223 215 44) ami06N w=9e-07 l=6e-07 as=1.71e-12 ad=1.71e-12 \
        ps=4.5e-06 pd=4.5e-06 m=1 region=sat
    \+323 (44 Memory\<4\> 212 44) ami06N w=9e-07 l=6e-07 as=1.71e-12 \
        ad=1.71e-12 ps=4.5e-06 pd=4.5e-06 m=1 region=sat
    \+298 (44 243 183 44) ami06N w=9e-07 l=6e-07 as=1.71e-12 ad=1.71e-12 \
        ps=4.5e-06 pd=4.5e-06 m=1 region=sat
    \+297 (44 244 184 44) ami06N w=9e-07 l=6e-07 as=1.71e-12 ad=1.71e-12 \
        ps=4.5e-06 pd=4.5e-06 m=1 region=sat
    \+296 (44 245 185 44) ami06N w=9e-07 l=6e-07 as=1.71e-12 ad=1.71e-12 \
        ps=4.5e-06 pd=4.5e-06 m=1 region=sat
    \+295 (44 246 186 44) ami06N w=9e-07 l=6e-07 as=1.71e-12 ad=1.71e-12 \
        ps=4.5e-06 pd=4.5e-06 m=1 region=sat
    \+294 (44 247 187 44) ami06N w=9e-07 l=6e-07 as=1.71e-12 ad=1.71e-12 \
        ps=4.5e-06 pd=4.5e-06 m=1 region=sat
    \+293 (44 240 180 44) ami06N w=9e-07 l=6e-07 as=1.71e-12 ad=1.71e-12 \
        ps=4.5e-06 pd=4.5e-06 m=1 region=sat
    \+292 (44 241 181 44) ami06N w=9e-07 l=6e-07 as=1.71e-12 ad=1.71e-12 \
        ps=4.5e-06 pd=4.5e-06 m=1 region=sat
    \+291 (44 242 182 44) ami06N w=9e-07 l=6e-07 as=1.71e-12 ad=1.71e-12 \
        ps=4.5e-06 pd=4.5e-06 m=1 region=sat
    \+257 (44 212 179 44) ami06N w=9e-07 l=6e-07 as=1.71e-12 ad=1.71e-12 \
        ps=4.5e-06 pd=4.5e-06 m=1 region=sat
    \+256 (44 Memory\<5\> 178 44) ami06N w=9e-07 l=6e-07 as=1.71e-12 \
        ad=1.71e-12 ps=4.5e-06 pd=4.5e-06 m=1 region=sat
    \+222 (44 178 161 44) ami06N w=9e-07 l=6e-07 as=1.71e-12 ad=1.71e-12 \
        ps=4.5e-06 pd=4.5e-06 m=1 region=sat
    \+197 (142 125 44 44) ami06N w=9e-07 l=6e-07 as=1.71e-12 ad=1.71e-12 \
        ps=4.5e-06 pd=4.5e-06 m=1 region=sat
    \+196 (143 126 44 44) ami06N w=9e-07 l=6e-07 as=1.71e-12 ad=1.71e-12 \
        ps=4.5e-06 pd=4.5e-06 m=1 region=sat
    \+195 (144 127 44 44) ami06N w=9e-07 l=6e-07 as=1.71e-12 ad=1.71e-12 \
        ps=4.5e-06 pd=4.5e-06 m=1 region=sat
    \+194 (137 120 44 44) ami06N w=9e-07 l=6e-07 as=1.71e-12 ad=1.71e-12 \
        ps=4.5e-06 pd=4.5e-06 m=1 region=sat
    \+193 (138 121 44 44) ami06N w=9e-07 l=6e-07 as=1.71e-12 ad=1.71e-12 \
        ps=4.5e-06 pd=4.5e-06 m=1 region=sat
    \+192 (139 122 44 44) ami06N w=9e-07 l=6e-07 as=1.71e-12 ad=1.71e-12 \
        ps=4.5e-06 pd=4.5e-06 m=1 region=sat
    \+191 (140 123 44 44) ami06N w=9e-07 l=6e-07 as=1.71e-12 ad=1.71e-12 \
        ps=4.5e-06 pd=4.5e-06 m=1 region=sat
    \+190 (141 124 44 44) ami06N w=9e-07 l=6e-07 as=1.71e-12 ad=1.71e-12 \
        ps=4.5e-06 pd=4.5e-06 m=1 region=sat
    \+157 (44 Memory\<6\> 136 44) ami06N w=9e-07 l=6e-07 as=1.71e-12 \
        ad=1.71e-12 ps=4.5e-06 pd=4.5e-06 m=1 region=sat
    \+131 (44 136 119 44) ami06N w=9e-07 l=6e-07 as=1.71e-12 ad=1.71e-12 \
        ps=4.5e-06 pd=4.5e-06 m=1 region=sat
    \+114 (44 Memory\<7\> 110 44) ami06N w=9e-07 l=6e-07 as=1.71e-12 \
        ad=1.71e-12 ps=4.5e-06 pd=4.5e-06 m=1 region=sat
    \+112 (44 110 109 44) ami06N w=9e-07 l=6e-07 as=1.71e-12 ad=1.71e-12 \
        ps=4.5e-06 pd=4.5e-06 m=1 region=sat
    \+63 (74 F2 73 44) ami06N w=9e-07 l=6e-07 as=1.71e-12 ad=1.71e-12 \
        ps=4.5e-06 pd=4.5e-06 m=1 region=sat
    \+62 (68 F1 84 44) ami06N w=9e-07 l=6e-07 as=1.71e-12 ad=1.71e-12 \
        ps=4.5e-06 pd=4.5e-06 m=1 region=sat
    \+61 (63 F1 74 44) ami06N w=9e-07 l=6e-07 as=1.71e-12 ad=1.71e-12 \
        ps=4.5e-06 pd=4.5e-06 m=1 region=sat
    \+60 (76 F2 75 44) ami06N w=9e-07 l=6e-07 as=1.71e-12 ad=1.71e-12 \
        ps=4.5e-06 pd=4.5e-06 m=1 region=sat
    \+59 (64 F1 76 44) ami06N w=9e-07 l=6e-07 as=1.71e-12 ad=1.71e-12 \
        ps=4.5e-06 pd=4.5e-06 m=1 region=sat
    \+58 (78 F2 77 44) ami06N w=9e-07 l=6e-07 as=1.71e-12 ad=1.71e-12 \
        ps=4.5e-06 pd=4.5e-06 m=1 region=sat
    \+57 (65 F1 78 44) ami06N w=9e-07 l=6e-07 as=1.71e-12 ad=1.71e-12 \
        ps=4.5e-06 pd=4.5e-06 m=1 region=sat
    \+56 (80 F2 79 44) ami06N w=9e-07 l=6e-07 as=1.71e-12 ad=1.71e-12 \
        ps=4.5e-06 pd=4.5e-06 m=1 region=sat
    \+55 (70 F2 69 44) ami06N w=9e-07 l=6e-07 as=1.71e-12 ad=1.71e-12 \
        ps=4.5e-06 pd=4.5e-06 m=1 region=sat
    \+54 (66 F1 80 44) ami06N w=9e-07 l=6e-07 as=1.71e-12 ad=1.71e-12 \
        ps=4.5e-06 pd=4.5e-06 m=1 region=sat
    \+53 (61 F1 70 44) ami06N w=9e-07 l=6e-07 as=1.71e-12 ad=1.71e-12 \
        ps=4.5e-06 pd=4.5e-06 m=1 region=sat
    \+52 (82 F2 81 44) ami06N w=9e-07 l=6e-07 as=1.71e-12 ad=1.71e-12 \
        ps=4.5e-06 pd=4.5e-06 m=1 region=sat
    \+51 (72 F2 71 44) ami06N w=9e-07 l=6e-07 as=1.71e-12 ad=1.71e-12 \
        ps=4.5e-06 pd=4.5e-06 m=1 region=sat
    \+50 (67 F1 82 44) ami06N w=9e-07 l=6e-07 as=1.71e-12 ad=1.71e-12 \
        ps=4.5e-06 pd=4.5e-06 m=1 region=sat
    \+49 (62 F1 72 44) ami06N w=9e-07 l=6e-07 as=1.71e-12 ad=1.71e-12 \
        ps=4.5e-06 pd=4.5e-06 m=1 region=sat
    \+48 (84 F2 83 44) ami06N w=9e-07 l=6e-07 as=1.71e-12 ad=1.71e-12 \
        ps=4.5e-06 pd=4.5e-06 m=1 region=sat
    \+758 (331 F1 Memory\<0\> 44) ami06N w=2.7e-06 l=6e-07 as=4.05e-12 \
        ad=4.05e-12 ps=5.7e-06 pd=5.7e-06 m=1 region=sat
    \+627 (257 F1 Memory\<1\> 44) ami06N w=2.7e-06 l=6e-07 as=4.05e-12 \
        ad=4.05e-12 ps=5.7e-06 pd=5.7e-06 m=1 region=sat
    \+504 (239 F1 Memory\<2\> 44) ami06N w=2.7e-06 l=6e-07 as=4.05e-12 \
        ad=4.05e-12 ps=5.7e-06 pd=5.7e-06 m=1 region=sat
    \+445 (229 F1 Memory\<3\> 44) ami06N w=2.7e-06 l=6e-07 as=4.05e-12 \
        ad=4.05e-12 ps=5.7e-06 pd=5.7e-06 m=1 region=sat
    \+290 (179 F1 Memory\<4\> 44) ami06N w=2.7e-06 l=6e-07 as=4.05e-12 \
        ad=4.05e-12 ps=5.7e-06 pd=5.7e-06 m=1 region=sat
    \+239 (161 F1 Memory\<5\> 44) ami06N w=2.7e-06 l=6e-07 as=4.05e-12 \
        ad=4.05e-12 ps=5.7e-06 pd=5.7e-06 m=1 region=sat
    \+148 (119 F1 Memory\<6\> 44) ami06N w=2.7e-06 l=6e-07 as=4.05e-12 \
        ad=4.05e-12 ps=5.7e-06 pd=5.7e-06 m=1 region=sat
    \+113 (109 F1 Memory\<7\> 44) ami06N w=2.7e-06 l=6e-07 as=4.05e-12 \
        ad=4.05e-12 ps=5.7e-06 pd=5.7e-06 m=1 region=sat
    \+1744 (603 602 vdd! vdd!) ami06P w=9e-07 l=6e-07 as=1.71e-12 \
        ad=1.71e-12 ps=4.5e-06 pd=4.5e-06 m=1 region=sat
    \+1743 (604 387 vdd! vdd!) ami06P w=9e-07 l=6e-07 as=1.71e-12 \
        ad=1.71e-12 ps=4.5e-06 pd=4.5e-06 m=1 region=sat
    \+1742 (605 604 vdd! vdd!) ami06P w=9e-07 l=6e-07 as=1.71e-12 \
        ad=1.71e-12 ps=4.5e-06 pd=4.5e-06 m=1 region=sat
    \+1741 (606 389 vdd! vdd!) ami06P w=9e-07 l=6e-07 as=1.71e-12 \
        ad=1.71e-12 ps=4.5e-06 pd=4.5e-06 m=1 region=sat
    \+1740 (607 606 vdd! vdd!) ami06P w=9e-07 l=6e-07 as=1.71e-12 \
        ad=1.71e-12 ps=4.5e-06 pd=4.5e-06 m=1 region=sat
    \+1739 (598 381 vdd! vdd!) ami06P w=9e-07 l=6e-07 as=1.71e-12 \
        ad=1.71e-12 ps=4.5e-06 pd=4.5e-06 m=1 region=sat
    \+1738 (599 598 vdd! vdd!) ami06P w=9e-07 l=6e-07 as=1.71e-12 \
        ad=1.71e-12 ps=4.5e-06 pd=4.5e-06 m=1 region=sat
    \+1737 (600 383 vdd! vdd!) ami06P w=9e-07 l=6e-07 as=1.71e-12 \
        ad=1.71e-12 ps=4.5e-06 pd=4.5e-06 m=1 region=sat
    \+1736 (601 600 vdd! vdd!) ami06P w=9e-07 l=6e-07 as=1.71e-12 \
        ad=1.71e-12 ps=4.5e-06 pd=4.5e-06 m=1 region=sat
    \+1735 (602 385 vdd! vdd!) ami06P w=9e-07 l=6e-07 as=1.71e-12 \
        ad=1.71e-12 ps=4.5e-06 pd=4.5e-06 m=1 region=sat
    \+1705 (574 375 vdd! vdd!) ami06P w=9e-07 l=6e-07 as=1.71e-12 \
        ad=1.71e-12 ps=4.5e-06 pd=4.5e-06 m=1 region=sat
    \+1704 (575 574 vdd! vdd!) ami06P w=9e-07 l=6e-07 as=1.71e-12 \
        ad=1.71e-12 ps=4.5e-06 pd=4.5e-06 m=1 region=sat
    \+1703 (576 376 vdd! vdd!) ami06P w=9e-07 l=6e-07 as=1.71e-12 \
        ad=1.71e-12 ps=4.5e-06 pd=4.5e-06 m=1 region=sat
    \+1702 (577 576 vdd! vdd!) ami06P w=9e-07 l=6e-07 as=1.71e-12 \
        ad=1.71e-12 ps=4.5e-06 pd=4.5e-06 m=1 region=sat
    \+1701 (578 377 vdd! vdd!) ami06P w=9e-07 l=6e-07 as=1.71e-12 \
        ad=1.71e-12 ps=4.5e-06 pd=4.5e-06 m=1 region=sat
    \+1700 (579 578 vdd! vdd!) ami06P w=9e-07 l=6e-07 as=1.71e-12 \
        ad=1.71e-12 ps=4.5e-06 pd=4.5e-06 m=1 region=sat
    \+1699 (580 378 vdd! vdd!) ami06P w=9e-07 l=6e-07 as=1.71e-12 \
        ad=1.71e-12 ps=4.5e-06 pd=4.5e-06 m=1 region=sat
    \+1698 (581 580 vdd! vdd!) ami06P w=9e-07 l=6e-07 as=1.71e-12 \
        ad=1.71e-12 ps=4.5e-06 pd=4.5e-06 m=1 region=sat
    \+1697 (582 379 vdd! vdd!) ami06P w=9e-07 l=6e-07 as=1.71e-12 \
        ad=1.71e-12 ps=4.5e-06 pd=4.5e-06 m=1 region=sat
    \+1696 (583 582 vdd! vdd!) ami06P w=9e-07 l=6e-07 as=1.71e-12 \
        ad=1.71e-12 ps=4.5e-06 pd=4.5e-06 m=1 region=sat
    \+1695 (584 380 vdd! vdd!) ami06P w=9e-07 l=6e-07 as=1.71e-12 \
        ad=1.71e-12 ps=4.5e-06 pd=4.5e-06 m=1 region=sat
    \+1694 (585 584 vdd! vdd!) ami06P w=9e-07 l=6e-07 as=1.71e-12 \
        ad=1.71e-12 ps=4.5e-06 pd=4.5e-06 m=1 region=sat
    \+1693 (570 373 vdd! vdd!) ami06P w=9e-07 l=6e-07 as=1.71e-12 \
        ad=1.71e-12 ps=4.5e-06 pd=4.5e-06 m=1 region=sat
    \+1692 (571 570 vdd! vdd!) ami06P w=9e-07 l=6e-07 as=1.71e-12 \
        ad=1.71e-12 ps=4.5e-06 pd=4.5e-06 m=1 region=sat
    \+1691 (572 374 vdd! vdd!) ami06P w=9e-07 l=6e-07 as=1.71e-12 \
        ad=1.71e-12 ps=4.5e-06 pd=4.5e-06 m=1 region=sat
    \+1690 (573 572 vdd! vdd!) ami06P w=9e-07 l=6e-07 as=1.71e-12 \
        ad=1.71e-12 ps=4.5e-06 pd=4.5e-06 m=1 region=sat
    \+1689 (560 vdd! vdd! vdd!) ami06P w=9e-07 l=6e-07 as=1.71e-12 \
        ad=1.71e-12 ps=4.5e-06 pd=4.5e-06 m=1 region=sat
    \+1688 (561 381 vdd! vdd!) ami06P w=9e-07 l=6e-07 as=1.71e-12 \
        ad=1.71e-12 ps=4.5e-06 pd=4.5e-06 m=1 region=sat
    \+1687 (562 594 vdd! vdd!) ami06P w=9e-07 l=6e-07 as=1.71e-12 \
        ad=1.71e-12 ps=4.5e-06 pd=4.5e-06 m=1 region=sat
    \+1686 (563 383 vdd! vdd!) ami06P w=9e-07 l=6e-07 as=1.71e-12 \
        ad=1.71e-12 ps=4.5e-06 pd=4.5e-06 m=1 region=sat
    \+1685 (564 595 vdd! vdd!) ami06P w=9e-07 l=6e-07 as=1.71e-12 \
        ad=1.71e-12 ps=4.5e-06 pd=4.5e-06 m=1 region=sat
    \+1684 (565 385 vdd! vdd!) ami06P w=9e-07 l=6e-07 as=1.71e-12 \
        ad=1.71e-12 ps=4.5e-06 pd=4.5e-06 m=1 region=sat
    \+1683 (566 596 vdd! vdd!) ami06P w=9e-07 l=6e-07 as=1.71e-12 \
        ad=1.71e-12 ps=4.5e-06 pd=4.5e-06 m=1 region=sat
    \+1682 (567 387 vdd! vdd!) ami06P w=9e-07 l=6e-07 as=1.71e-12 \
        ad=1.71e-12 ps=4.5e-06 pd=4.5e-06 m=1 region=sat
    \+1681 (568 597 vdd! vdd!) ami06P w=9e-07 l=6e-07 as=1.71e-12 \
        ad=1.71e-12 ps=4.5e-06 pd=4.5e-06 m=1 region=sat
    \+1680 (569 389 vdd! vdd!) ami06P w=9e-07 l=6e-07 as=1.71e-12 \
        ad=1.71e-12 ps=4.5e-06 pd=4.5e-06 m=1 region=sat
    \+1679 (395 525 vdd! vdd!) ami06P w=9e-07 l=6e-07 as=1.71e-12 \
        ad=1.71e-12 ps=4.5e-06 pd=4.5e-06 m=1 region=sat
    \+1678 (396 526 vdd! vdd!) ami06P w=9e-07 l=6e-07 as=1.71e-12 \
        ad=1.71e-12 ps=4.5e-06 pd=4.5e-06 m=1 region=sat
    \+1677 (397 527 vdd! vdd!) ami06P w=9e-07 l=6e-07 as=1.71e-12 \
        ad=1.71e-12 ps=4.5e-06 pd=4.5e-06 m=1 region=sat
    \+1676 (398 528 vdd! vdd!) ami06P w=9e-07 l=6e-07 as=1.71e-12 \
        ad=1.71e-12 ps=4.5e-06 pd=4.5e-06 m=1 region=sat
    \+1675 (399 529 vdd! vdd!) ami06P w=9e-07 l=6e-07 as=1.71e-12 \
        ad=1.71e-12 ps=4.5e-06 pd=4.5e-06 m=1 region=sat
    \+1674 (400 530 vdd! vdd!) ami06P w=9e-07 l=6e-07 as=1.71e-12 \
        ad=1.71e-12 ps=4.5e-06 pd=4.5e-06 m=1 region=sat
    \+1673 (373 508 vdd! vdd!) ami06P w=9e-07 l=6e-07 as=1.71e-12 \
        ad=1.71e-12 ps=4.5e-06 pd=4.5e-06 m=1 region=sat
    \+1672 (401 531 vdd! vdd!) ami06P w=9e-07 l=6e-07 as=1.71e-12 \
        ad=1.71e-12 ps=4.5e-06 pd=4.5e-06 m=1 region=sat
    \+1671 (374 509 vdd! vdd!) ami06P w=9e-07 l=6e-07 as=1.71e-12 \
        ad=1.71e-12 ps=4.5e-06 pd=4.5e-06 m=1 region=sat
    \+1670 (402 532 vdd! vdd!) ami06P w=9e-07 l=6e-07 as=1.71e-12 \
        ad=1.71e-12 ps=4.5e-06 pd=4.5e-06 m=1 region=sat
    \+1669 (375 510 vdd! vdd!) ami06P w=9e-07 l=6e-07 as=1.71e-12 \
        ad=1.71e-12 ps=4.5e-06 pd=4.5e-06 m=1 region=sat
    \+1668 (403 533 vdd! vdd!) ami06P w=9e-07 l=6e-07 as=1.71e-12 \
        ad=1.71e-12 ps=4.5e-06 pd=4.5e-06 m=1 region=sat
    \+1667 (376 511 vdd! vdd!) ami06P w=9e-07 l=6e-07 as=1.71e-12 \
        ad=1.71e-12 ps=4.5e-06 pd=4.5e-06 m=1 region=sat
    \+1666 (377 512 vdd! vdd!) ami06P w=9e-07 l=6e-07 as=1.71e-12 \
        ad=1.71e-12 ps=4.5e-06 pd=4.5e-06 m=1 region=sat
    \+1665 (378 513 vdd! vdd!) ami06P w=9e-07 l=6e-07 as=1.71e-12 \
        ad=1.71e-12 ps=4.5e-06 pd=4.5e-06 m=1 region=sat
    \+1664 (379 514 vdd! vdd!) ami06P w=9e-07 l=6e-07 as=1.71e-12 \
        ad=1.71e-12 ps=4.5e-06 pd=4.5e-06 m=1 region=sat
    \+1663 (380 515 vdd! vdd!) ami06P w=9e-07 l=6e-07 as=1.71e-12 \
        ad=1.71e-12 ps=4.5e-06 pd=4.5e-06 m=1 region=sat
    \+1662 (381 516 vdd! vdd!) ami06P w=9e-07 l=6e-07 as=1.71e-12 \
        ad=1.71e-12 ps=4.5e-06 pd=4.5e-06 m=1 region=sat
    \+1661 (383 517 vdd! vdd!) ami06P w=9e-07 l=6e-07 as=1.71e-12 \
        ad=1.71e-12 ps=4.5e-06 pd=4.5e-06 m=1 region=sat
    \+1660 (385 518 vdd! vdd!) ami06P w=9e-07 l=6e-07 as=1.71e-12 \
        ad=1.71e-12 ps=4.5e-06 pd=4.5e-06 m=1 region=sat
    \+1659 (387 519 vdd! vdd!) ami06P w=9e-07 l=6e-07 as=1.71e-12 \
        ad=1.71e-12 ps=4.5e-06 pd=4.5e-06 m=1 region=sat
    \+1658 (389 520 vdd! vdd!) ami06P w=9e-07 l=6e-07 as=1.71e-12 \
        ad=1.71e-12 ps=4.5e-06 pd=4.5e-06 m=1 region=sat
    \+1657 (391 521 vdd! vdd!) ami06P w=9e-07 l=6e-07 as=1.71e-12 \
        ad=1.71e-12 ps=4.5e-06 pd=4.5e-06 m=1 region=sat
    \+1656 (392 522 vdd! vdd!) ami06P w=9e-07 l=6e-07 as=1.71e-12 \
        ad=1.71e-12 ps=4.5e-06 pd=4.5e-06 m=1 region=sat
    \+1655 (393 523 vdd! vdd!) ami06P w=9e-07 l=6e-07 as=1.71e-12 \
        ad=1.71e-12 ps=4.5e-06 pd=4.5e-06 m=1 region=sat
    \+1654 (394 524 vdd! vdd!) ami06P w=9e-07 l=6e-07 as=1.71e-12 \
        ad=1.71e-12 ps=4.5e-06 pd=4.5e-06 m=1 region=sat
    \+1653 (vdd! 398 554 vdd!) ami06P w=9e-07 l=6e-07 as=1.71e-12 \
        ad=1.71e-12 ps=4.5e-06 pd=4.5e-06 m=1 region=sat
    \+1652 (vdd! 399 555 vdd!) ami06P w=9e-07 l=6e-07 as=1.71e-12 \
        ad=1.71e-12 ps=4.5e-06 pd=4.5e-06 m=1 region=sat
    \+1651 (vdd! 400 556 vdd!) ami06P w=9e-07 l=6e-07 as=1.71e-12 \
        ad=1.71e-12 ps=4.5e-06 pd=4.5e-06 m=1 region=sat
    \+1650 (vdd! 373 534 vdd!) ami06P w=9e-07 l=6e-07 as=1.71e-12 \
        ad=1.71e-12 ps=4.5e-06 pd=4.5e-06 m=1 region=sat
    \+1649 (vdd! 401 557 vdd!) ami06P w=9e-07 l=6e-07 as=1.71e-12 \
        ad=1.71e-12 ps=4.5e-06 pd=4.5e-06 m=1 region=sat
    \+1648 (vdd! 374 535 vdd!) ami06P w=9e-07 l=6e-07 as=1.71e-12 \
        ad=1.71e-12 ps=4.5e-06 pd=4.5e-06 m=1 region=sat
    \+1647 (vdd! 402 558 vdd!) ami06P w=9e-07 l=6e-07 as=1.71e-12 \
        ad=1.71e-12 ps=4.5e-06 pd=4.5e-06 m=1 region=sat
    \+1646 (vdd! 375 536 vdd!) ami06P w=9e-07 l=6e-07 as=1.71e-12 \
        ad=1.71e-12 ps=4.5e-06 pd=4.5e-06 m=1 region=sat
    \+1645 (vdd! 403 559 vdd!) ami06P w=9e-07 l=6e-07 as=1.71e-12 \
        ad=1.71e-12 ps=4.5e-06 pd=4.5e-06 m=1 region=sat
    \+1644 (vdd! 376 537 vdd!) ami06P w=9e-07 l=6e-07 as=1.71e-12 \
        ad=1.71e-12 ps=4.5e-06 pd=4.5e-06 m=1 region=sat
    \+1643 (vdd! 377 538 vdd!) ami06P w=9e-07 l=6e-07 as=1.71e-12 \
        ad=1.71e-12 ps=4.5e-06 pd=4.5e-06 m=1 region=sat
    \+1642 (vdd! 378 539 vdd!) ami06P w=9e-07 l=6e-07 as=1.71e-12 \
        ad=1.71e-12 ps=4.5e-06 pd=4.5e-06 m=1 region=sat
    \+1641 (vdd! 379 540 vdd!) ami06P w=9e-07 l=6e-07 as=1.71e-12 \
        ad=1.71e-12 ps=4.5e-06 pd=4.5e-06 m=1 region=sat
    \+1640 (vdd! 380 541 vdd!) ami06P w=9e-07 l=6e-07 as=1.71e-12 \
        ad=1.71e-12 ps=4.5e-06 pd=4.5e-06 m=1 region=sat
    \+1639 (vdd! 381 542 vdd!) ami06P w=9e-07 l=6e-07 as=1.71e-12 \
        ad=1.71e-12 ps=4.5e-06 pd=4.5e-06 m=1 region=sat
    \+1638 (vdd! 383 543 vdd!) ami06P w=9e-07 l=6e-07 as=1.71e-12 \
        ad=1.71e-12 ps=4.5e-06 pd=4.5e-06 m=1 region=sat
    \+1637 (vdd! 385 544 vdd!) ami06P w=9e-07 l=6e-07 as=1.71e-12 \
        ad=1.71e-12 ps=4.5e-06 pd=4.5e-06 m=1 region=sat
    \+1636 (vdd! 387 545 vdd!) ami06P w=9e-07 l=6e-07 as=1.71e-12 \
        ad=1.71e-12 ps=4.5e-06 pd=4.5e-06 m=1 region=sat
    \+1635 (vdd! 389 546 vdd!) ami06P w=9e-07 l=6e-07 as=1.71e-12 \
        ad=1.71e-12 ps=4.5e-06 pd=4.5e-06 m=1 region=sat
    \+1634 (vdd! 391 547 vdd!) ami06P w=9e-07 l=6e-07 as=1.71e-12 \
        ad=1.71e-12 ps=4.5e-06 pd=4.5e-06 m=1 region=sat
    \+1633 (vdd! 392 548 vdd!) ami06P w=9e-07 l=6e-07 as=1.71e-12 \
        ad=1.71e-12 ps=4.5e-06 pd=4.5e-06 m=1 region=sat
    \+1632 (vdd! 393 549 vdd!) ami06P w=9e-07 l=6e-07 as=1.71e-12 \
        ad=1.71e-12 ps=4.5e-06 pd=4.5e-06 m=1 region=sat
    \+1631 (vdd! 394 550 vdd!) ami06P w=9e-07 l=6e-07 as=1.71e-12 \
        ad=1.71e-12 ps=4.5e-06 pd=4.5e-06 m=1 region=sat
    \+1630 (vdd! 395 551 vdd!) ami06P w=9e-07 l=6e-07 as=1.71e-12 \
        ad=1.71e-12 ps=4.5e-06 pd=4.5e-06 m=1 region=sat
    \+1629 (vdd! 396 552 vdd!) ami06P w=9e-07 l=6e-07 as=1.71e-12 \
        ad=1.71e-12 ps=4.5e-06 pd=4.5e-06 m=1 region=sat
    \+1628 (vdd! 397 553 vdd!) ami06P w=9e-07 l=6e-07 as=1.71e-12 \
        ad=1.71e-12 ps=4.5e-06 pd=4.5e-06 m=1 region=sat
    \+1627 (482 431 vdd! vdd!) ami06P w=9e-07 l=6e-07 as=1.71e-12 \
        ad=1.71e-12 ps=4.5e-06 pd=4.5e-06 m=1 region=sat
    \+1626 (505 477 vdd! vdd!) ami06P w=9e-07 l=6e-07 as=1.71e-12 \
        ad=1.71e-12 ps=4.5e-06 pd=4.5e-06 m=1 region=sat
    \+1625 (483 433 vdd! vdd!) ami06P w=9e-07 l=6e-07 as=1.71e-12 \
        ad=1.71e-12 ps=4.5e-06 pd=4.5e-06 m=1 region=sat
    \+1624 (506 479 vdd! vdd!) ami06P w=9e-07 l=6e-07 as=1.71e-12 \
        ad=1.71e-12 ps=4.5e-06 pd=4.5e-06 m=1 region=sat
    \+1623 (484 435 vdd! vdd!) ami06P w=9e-07 l=6e-07 as=1.71e-12 \
        ad=1.71e-12 ps=4.5e-06 pd=4.5e-06 m=1 region=sat
    \+1622 (507 481 vdd! vdd!) ami06P w=9e-07 l=6e-07 as=1.71e-12 \
        ad=1.71e-12 ps=4.5e-06 pd=4.5e-06 m=1 region=sat
    \+1621 (485 437 vdd! vdd!) ami06P w=9e-07 l=6e-07 as=1.71e-12 \
        ad=1.71e-12 ps=4.5e-06 pd=4.5e-06 m=1 region=sat
    \+1620 (486 439 vdd! vdd!) ami06P w=9e-07 l=6e-07 as=1.71e-12 \
        ad=1.71e-12 ps=4.5e-06 pd=4.5e-06 m=1 region=sat
    \+1619 (487 441 vdd! vdd!) ami06P w=9e-07 l=6e-07 as=1.71e-12 \
        ad=1.71e-12 ps=4.5e-06 pd=4.5e-06 m=1 region=sat
    \+1618 (488 443 vdd! vdd!) ami06P w=9e-07 l=6e-07 as=1.71e-12 \
        ad=1.71e-12 ps=4.5e-06 pd=4.5e-06 m=1 region=sat
    \+1617 (489 445 vdd! vdd!) ami06P w=9e-07 l=6e-07 as=1.71e-12 \
        ad=1.71e-12 ps=4.5e-06 pd=4.5e-06 m=1 region=sat
    \+1616 (490 447 vdd! vdd!) ami06P w=9e-07 l=6e-07 as=1.71e-12 \
        ad=1.71e-12 ps=4.5e-06 pd=4.5e-06 m=1 region=sat
    \+1615 (491 449 vdd! vdd!) ami06P w=9e-07 l=6e-07 as=1.71e-12 \
        ad=1.71e-12 ps=4.5e-06 pd=4.5e-06 m=1 region=sat
    \+1614 (492 451 vdd! vdd!) ami06P w=9e-07 l=6e-07 as=1.71e-12 \
        ad=1.71e-12 ps=4.5e-06 pd=4.5e-06 m=1 region=sat
    \+1613 (493 453 vdd! vdd!) ami06P w=9e-07 l=6e-07 as=1.71e-12 \
        ad=1.71e-12 ps=4.5e-06 pd=4.5e-06 m=1 region=sat
    \+1612 (494 455 vdd! vdd!) ami06P w=9e-07 l=6e-07 as=1.71e-12 \
        ad=1.71e-12 ps=4.5e-06 pd=4.5e-06 m=1 region=sat
    \+1611 (495 457 vdd! vdd!) ami06P w=9e-07 l=6e-07 as=1.71e-12 \
        ad=1.71e-12 ps=4.5e-06 pd=4.5e-06 m=1 region=sat
    \+1610 (496 459 vdd! vdd!) ami06P w=9e-07 l=6e-07 as=1.71e-12 \
        ad=1.71e-12 ps=4.5e-06 pd=4.5e-06 m=1 region=sat
    \+1609 (497 461 vdd! vdd!) ami06P w=9e-07 l=6e-07 as=1.71e-12 \
        ad=1.71e-12 ps=4.5e-06 pd=4.5e-06 m=1 region=sat
    \+1608 (498 463 vdd! vdd!) ami06P w=9e-07 l=6e-07 as=1.71e-12 \
        ad=1.71e-12 ps=4.5e-06 pd=4.5e-06 m=1 region=sat
    \+1607 (499 465 vdd! vdd!) ami06P w=9e-07 l=6e-07 as=1.71e-12 \
        ad=1.71e-12 ps=4.5e-06 pd=4.5e-06 m=1 region=sat
    \+1606 (500 467 vdd! vdd!) ami06P w=9e-07 l=6e-07 as=1.71e-12 \
        ad=1.71e-12 ps=4.5e-06 pd=4.5e-06 m=1 region=sat
    \+1605 (501 469 vdd! vdd!) ami06P w=9e-07 l=6e-07 as=1.71e-12 \
        ad=1.71e-12 ps=4.5e-06 pd=4.5e-06 m=1 region=sat
    \+1604 (502 471 vdd! vdd!) ami06P w=9e-07 l=6e-07 as=1.71e-12 \
        ad=1.71e-12 ps=4.5e-06 pd=4.5e-06 m=1 region=sat
    \+1603 (503 473 vdd! vdd!) ami06P w=9e-07 l=6e-07 as=1.71e-12 \
        ad=1.71e-12 ps=4.5e-06 pd=4.5e-06 m=1 region=sat
    \+1602 (504 475 vdd! vdd!) ami06P w=9e-07 l=6e-07 as=1.71e-12 \
        ad=1.71e-12 ps=4.5e-06 pd=4.5e-06 m=1 region=sat
    \+1601 (vdd! 485 436 vdd!) ami06P w=9e-07 l=6e-07 as=1.71e-12 \
        ad=1.71e-12 ps=4.5e-06 pd=4.5e-06 m=1 region=sat
    \+1600 (vdd! 486 438 vdd!) ami06P w=9e-07 l=6e-07 as=1.71e-12 \
        ad=1.71e-12 ps=4.5e-06 pd=4.5e-06 m=1 region=sat
    \+1599 (vdd! 487 440 vdd!) ami06P w=9e-07 l=6e-07 as=1.71e-12 \
        ad=1.71e-12 ps=4.5e-06 pd=4.5e-06 m=1 region=sat
    \+1598 (vdd! 488 442 vdd!) ami06P w=9e-07 l=6e-07 as=1.71e-12 \
        ad=1.71e-12 ps=4.5e-06 pd=4.5e-06 m=1 region=sat
    \+1597 (vdd! 489 444 vdd!) ami06P w=9e-07 l=6e-07 as=1.71e-12 \
        ad=1.71e-12 ps=4.5e-06 pd=4.5e-06 m=1 region=sat
    \+1596 (vdd! 490 446 vdd!) ami06P w=9e-07 l=6e-07 as=1.71e-12 \
        ad=1.71e-12 ps=4.5e-06 pd=4.5e-06 m=1 region=sat
    \+1595 (vdd! 491 448 vdd!) ami06P w=9e-07 l=6e-07 as=1.71e-12 \
        ad=1.71e-12 ps=4.5e-06 pd=4.5e-06 m=1 region=sat
    \+1594 (vdd! 492 450 vdd!) ami06P w=9e-07 l=6e-07 as=1.71e-12 \
        ad=1.71e-12 ps=4.5e-06 pd=4.5e-06 m=1 region=sat
    \+1593 (vdd! 493 452 vdd!) ami06P w=9e-07 l=6e-07 as=1.71e-12 \
        ad=1.71e-12 ps=4.5e-06 pd=4.5e-06 m=1 region=sat
    \+1592 (vdd! 494 454 vdd!) ami06P w=9e-07 l=6e-07 as=1.71e-12 \
        ad=1.71e-12 ps=4.5e-06 pd=4.5e-06 m=1 region=sat
    \+1591 (vdd! 495 456 vdd!) ami06P w=9e-07 l=6e-07 as=1.71e-12 \
        ad=1.71e-12 ps=4.5e-06 pd=4.5e-06 m=1 region=sat
    \+1590 (vdd! 496 458 vdd!) ami06P w=9e-07 l=6e-07 as=1.71e-12 \
        ad=1.71e-12 ps=4.5e-06 pd=4.5e-06 m=1 region=sat
    \+1589 (vdd! 497 460 vdd!) ami06P w=9e-07 l=6e-07 as=1.71e-12 \
        ad=1.71e-12 ps=4.5e-06 pd=4.5e-06 m=1 region=sat
    \+1588 (vdd! 498 462 vdd!) ami06P w=9e-07 l=6e-07 as=1.71e-12 \
        ad=1.71e-12 ps=4.5e-06 pd=4.5e-06 m=1 region=sat
    \+1587 (vdd! 499 464 vdd!) ami06P w=9e-07 l=6e-07 as=1.71e-12 \
        ad=1.71e-12 ps=4.5e-06 pd=4.5e-06 m=1 region=sat
    \+1586 (vdd! 500 466 vdd!) ami06P w=9e-07 l=6e-07 as=1.71e-12 \
        ad=1.71e-12 ps=4.5e-06 pd=4.5e-06 m=1 region=sat
    \+1585 (vdd! 501 468 vdd!) ami06P w=9e-07 l=6e-07 as=1.71e-12 \
        ad=1.71e-12 ps=4.5e-06 pd=4.5e-06 m=1 region=sat
    \+1584 (vdd! 502 470 vdd!) ami06P w=9e-07 l=6e-07 as=1.71e-12 \
        ad=1.71e-12 ps=4.5e-06 pd=4.5e-06 m=1 region=sat
    \+1583 (vdd! 503 472 vdd!) ami06P w=9e-07 l=6e-07 as=1.71e-12 \
        ad=1.71e-12 ps=4.5e-06 pd=4.5e-06 m=1 region=sat
    \+1582 (vdd! 504 474 vdd!) ami06P w=9e-07 l=6e-07 as=1.71e-12 \
        ad=1.71e-12 ps=4.5e-06 pd=4.5e-06 m=1 region=sat
    \+1581 (vdd! 505 476 vdd!) ami06P w=9e-07 l=6e-07 as=1.71e-12 \
        ad=1.71e-12 ps=4.5e-06 pd=4.5e-06 m=1 region=sat
    \+1580 (vdd! 482 430 vdd!) ami06P w=9e-07 l=6e-07 as=1.71e-12 \
        ad=1.71e-12 ps=4.5e-06 pd=4.5e-06 m=1 region=sat
    \+1579 (vdd! 506 478 vdd!) ami06P w=9e-07 l=6e-07 as=1.71e-12 \
        ad=1.71e-12 ps=4.5e-06 pd=4.5e-06 m=1 region=sat
    \+1578 (vdd! 483 432 vdd!) ami06P w=9e-07 l=6e-07 as=1.71e-12 \
        ad=1.71e-12 ps=4.5e-06 pd=4.5e-06 m=1 region=sat
    \+1577 (vdd! 507 480 vdd!) ami06P w=9e-07 l=6e-07 as=1.71e-12 \
        ad=1.71e-12 ps=4.5e-06 pd=4.5e-06 m=1 region=sat
    \+1576 (vdd! 484 434 vdd!) ami06P w=9e-07 l=6e-07 as=1.71e-12 \
        ad=1.71e-12 ps=4.5e-06 pd=4.5e-06 m=1 region=sat
    \+1557 (350 349 vdd! vdd!) ami06P w=9e-07 l=6e-07 as=1.71e-12 \
        ad=1.71e-12 ps=4.5e-06 pd=4.5e-06 m=1 region=sat
    \+1556 (361 246 vdd! vdd!) ami06P w=9e-07 l=6e-07 as=1.71e-12 \
        ad=1.71e-12 ps=4.5e-06 pd=4.5e-06 m=1 region=sat
    \+1555 (351 241 vdd! vdd!) ami06P w=9e-07 l=6e-07 as=1.71e-12 \
        ad=1.71e-12 ps=4.5e-06 pd=4.5e-06 m=1 region=sat
    \+1554 (362 361 vdd! vdd!) ami06P w=9e-07 l=6e-07 as=1.71e-12 \
        ad=1.71e-12 ps=4.5e-06 pd=4.5e-06 m=1 region=sat
    \+1553 (352 351 vdd! vdd!) ami06P w=9e-07 l=6e-07 as=1.71e-12 \
        ad=1.71e-12 ps=4.5e-06 pd=4.5e-06 m=1 region=sat
    \+1552 (363 247 vdd! vdd!) ami06P w=9e-07 l=6e-07 as=1.71e-12 \
        ad=1.71e-12 ps=4.5e-06 pd=4.5e-06 m=1 region=sat
    \+1551 (353 242 vdd! vdd!) ami06P w=9e-07 l=6e-07 as=1.71e-12 \
        ad=1.71e-12 ps=4.5e-06 pd=4.5e-06 m=1 region=sat
    \+1550 (364 363 vdd! vdd!) ami06P w=9e-07 l=6e-07 as=1.71e-12 \
        ad=1.71e-12 ps=4.5e-06 pd=4.5e-06 m=1 region=sat
    \+1549 (354 353 vdd! vdd!) ami06P w=9e-07 l=6e-07 as=1.71e-12 \
        ad=1.71e-12 ps=4.5e-06 pd=4.5e-06 m=1 region=sat
    \+1548 (355 243 vdd! vdd!) ami06P w=9e-07 l=6e-07 as=1.71e-12 \
        ad=1.71e-12 ps=4.5e-06 pd=4.5e-06 m=1 region=sat
    \+1547 (356 355 vdd! vdd!) ami06P w=9e-07 l=6e-07 as=1.71e-12 \
        ad=1.71e-12 ps=4.5e-06 pd=4.5e-06 m=1 region=sat
    \+1546 (357 244 vdd! vdd!) ami06P w=9e-07 l=6e-07 as=1.71e-12 \
        ad=1.71e-12 ps=4.5e-06 pd=4.5e-06 m=1 region=sat
    \+1545 (358 357 vdd! vdd!) ami06P w=9e-07 l=6e-07 as=1.71e-12 \
        ad=1.71e-12 ps=4.5e-06 pd=4.5e-06 m=1 region=sat
    \+1544 (359 245 vdd! vdd!) ami06P w=9e-07 l=6e-07 as=1.71e-12 \
        ad=1.71e-12 ps=4.5e-06 pd=4.5e-06 m=1 region=sat
    \+1543 (349 240 vdd! vdd!) ami06P w=9e-07 l=6e-07 as=1.71e-12 \
        ad=1.71e-12 ps=4.5e-06 pd=4.5e-06 m=1 region=sat
    \+1542 (360 359 vdd! vdd!) ami06P w=9e-07 l=6e-07 as=1.71e-12 \
        ad=1.71e-12 ps=4.5e-06 pd=4.5e-06 m=1 region=sat
    \+1540 (240 307 vdd! vdd!) ami06P w=9e-07 l=6e-07 as=1.71e-12 \
        ad=1.71e-12 ps=4.5e-06 pd=4.5e-06 m=1 region=sat
    \+1539 (241 308 vdd! vdd!) ami06P w=9e-07 l=6e-07 as=1.71e-12 \
        ad=1.71e-12 ps=4.5e-06 pd=4.5e-06 m=1 region=sat
    \+1538 (242 309 vdd! vdd!) ami06P w=9e-07 l=6e-07 as=1.71e-12 \
        ad=1.71e-12 ps=4.5e-06 pd=4.5e-06 m=1 region=sat
    \+1537 (243 310 vdd! vdd!) ami06P w=9e-07 l=6e-07 as=1.71e-12 \
        ad=1.71e-12 ps=4.5e-06 pd=4.5e-06 m=1 region=sat
    \+1536 (244 311 vdd! vdd!) ami06P w=9e-07 l=6e-07 as=1.71e-12 \
        ad=1.71e-12 ps=4.5e-06 pd=4.5e-06 m=1 region=sat
    \+1535 (245 312 vdd! vdd!) ami06P w=9e-07 l=6e-07 as=1.71e-12 \
        ad=1.71e-12 ps=4.5e-06 pd=4.5e-06 m=1 region=sat
    \+1534 (246 313 vdd! vdd!) ami06P w=9e-07 l=6e-07 as=1.71e-12 \
        ad=1.71e-12 ps=4.5e-06 pd=4.5e-06 m=1 region=sat
    \+1533 (247 314 vdd! vdd!) ami06P w=9e-07 l=6e-07 as=1.71e-12 \
        ad=1.71e-12 ps=4.5e-06 pd=4.5e-06 m=1 region=sat
    \+1532 (vdd! 247 330 vdd!) ami06P w=9e-07 l=6e-07 as=1.71e-12 \
        ad=1.71e-12 ps=4.5e-06 pd=4.5e-06 m=1 region=sat
    \+1531 (vdd! 240 323 vdd!) ami06P w=9e-07 l=6e-07 as=1.71e-12 \
        ad=1.71e-12 ps=4.5e-06 pd=4.5e-06 m=1 region=sat
    \+1530 (vdd! 241 324 vdd!) ami06P w=9e-07 l=6e-07 as=1.71e-12 \
        ad=1.71e-12 ps=4.5e-06 pd=4.5e-06 m=1 region=sat
    \+1529 (vdd! 242 325 vdd!) ami06P w=9e-07 l=6e-07 as=1.71e-12 \
        ad=1.71e-12 ps=4.5e-06 pd=4.5e-06 m=1 region=sat
    \+1528 (vdd! 243 326 vdd!) ami06P w=9e-07 l=6e-07 as=1.71e-12 \
        ad=1.71e-12 ps=4.5e-06 pd=4.5e-06 m=1 region=sat
    \+1527 (vdd! 244 327 vdd!) ami06P w=9e-07 l=6e-07 as=1.71e-12 \
        ad=1.71e-12 ps=4.5e-06 pd=4.5e-06 m=1 region=sat
    \+1526 (vdd! 245 328 vdd!) ami06P w=9e-07 l=6e-07 as=1.71e-12 \
        ad=1.71e-12 ps=4.5e-06 pd=4.5e-06 m=1 region=sat
    \+1525 (vdd! 246 329 vdd!) ami06P w=9e-07 l=6e-07 as=1.71e-12 \
        ad=1.71e-12 ps=4.5e-06 pd=4.5e-06 m=1 region=sat
    \+1524 (319 303 vdd! vdd!) ami06P w=9e-07 l=6e-07 as=1.71e-12 \
        ad=1.71e-12 ps=4.5e-06 pd=4.5e-06 m=1 region=sat
    \+1523 (320 304 vdd! vdd!) ami06P w=9e-07 l=6e-07 as=1.71e-12 \
        ad=1.71e-12 ps=4.5e-06 pd=4.5e-06 m=1 region=sat
    \+1522 (321 305 vdd! vdd!) ami06P w=9e-07 l=6e-07 as=1.71e-12 \
        ad=1.71e-12 ps=4.5e-06 pd=4.5e-06 m=1 region=sat
    \+1521 (322 306 vdd! vdd!) ami06P w=9e-07 l=6e-07 as=1.71e-12 \
        ad=1.71e-12 ps=4.5e-06 pd=4.5e-06 m=1 region=sat
    \+1520 (315 299 vdd! vdd!) ami06P w=9e-07 l=6e-07 as=1.71e-12 \
        ad=1.71e-12 ps=4.5e-06 pd=4.5e-06 m=1 region=sat
    \+1519 (316 300 vdd! vdd!) ami06P w=9e-07 l=6e-07 as=1.71e-12 \
        ad=1.71e-12 ps=4.5e-06 pd=4.5e-06 m=1 region=sat
    \+1518 (317 301 vdd! vdd!) ami06P w=9e-07 l=6e-07 as=1.71e-12 \
        ad=1.71e-12 ps=4.5e-06 pd=4.5e-06 m=1 region=sat
    \+1517 (318 302 vdd! vdd!) ami06P w=9e-07 l=6e-07 as=1.71e-12 \
        ad=1.71e-12 ps=4.5e-06 pd=4.5e-06 m=1 region=sat
    \+1516 (vdd! 334 300 vdd!) ami06P w=9e-07 l=6e-07 as=1.71e-12 \
        ad=1.71e-12 ps=4.5e-06 pd=4.5e-06 m=1 region=sat
    \+1515 (vdd! 336 301 vdd!) ami06P w=9e-07 l=6e-07 as=1.71e-12 \
        ad=1.71e-12 ps=4.5e-06 pd=4.5e-06 m=1 region=sat
    \+1514 (vdd! 338 302 vdd!) ami06P w=9e-07 l=6e-07 as=1.71e-12 \
        ad=1.71e-12 ps=4.5e-06 pd=4.5e-06 m=1 region=sat
    \+1513 (vdd! 340 303 vdd!) ami06P w=9e-07 l=6e-07 as=1.71e-12 \
        ad=1.71e-12 ps=4.5e-06 pd=4.5e-06 m=1 region=sat
    \+1512 (vdd! 342 304 vdd!) ami06P w=9e-07 l=6e-07 as=1.71e-12 \
        ad=1.71e-12 ps=4.5e-06 pd=4.5e-06 m=1 region=sat
    \+1511 (vdd! 344 305 vdd!) ami06P w=9e-07 l=6e-07 as=1.71e-12 \
        ad=1.71e-12 ps=4.5e-06 pd=4.5e-06 m=1 region=sat
    \+1510 (vdd! 346 306 vdd!) ami06P w=9e-07 l=6e-07 as=1.71e-12 \
        ad=1.71e-12 ps=4.5e-06 pd=4.5e-06 m=1 region=sat
    \+1509 (vdd! 332 299 vdd!) ami06P w=9e-07 l=6e-07 as=1.71e-12 \
        ad=1.71e-12 ps=4.5e-06 pd=4.5e-06 m=1 region=sat
    \+1506 (291 259 vdd! vdd!) ami06P w=9e-07 l=6e-07 as=1.71e-12 \
        ad=1.71e-12 ps=4.5e-06 pd=4.5e-06 m=1 region=sat
    \+1505 (292 261 vdd! vdd!) ami06P w=9e-07 l=6e-07 as=1.71e-12 \
        ad=1.71e-12 ps=4.5e-06 pd=4.5e-06 m=1 region=sat
    \+1504 (293 263 vdd! vdd!) ami06P w=9e-07 l=6e-07 as=1.71e-12 \
        ad=1.71e-12 ps=4.5e-06 pd=4.5e-06 m=1 region=sat
    \+1503 (294 265 vdd! vdd!) ami06P w=9e-07 l=6e-07 as=1.71e-12 \
        ad=1.71e-12 ps=4.5e-06 pd=4.5e-06 m=1 region=sat
    \+1502 (295 267 vdd! vdd!) ami06P w=9e-07 l=6e-07 as=1.71e-12 \
        ad=1.71e-12 ps=4.5e-06 pd=4.5e-06 m=1 region=sat
    \+1501 (296 269 vdd! vdd!) ami06P w=9e-07 l=6e-07 as=1.71e-12 \
        ad=1.71e-12 ps=4.5e-06 pd=4.5e-06 m=1 region=sat
    \+1500 (297 271 vdd! vdd!) ami06P w=9e-07 l=6e-07 as=1.71e-12 \
        ad=1.71e-12 ps=4.5e-06 pd=4.5e-06 m=1 region=sat
    \+1499 (298 273 vdd! vdd!) ami06P w=9e-07 l=6e-07 as=1.71e-12 \
        ad=1.71e-12 ps=4.5e-06 pd=4.5e-06 m=1 region=sat
    \+1498 (vdd! 291 258 vdd!) ami06P w=9e-07 l=6e-07 as=1.71e-12 \
        ad=1.71e-12 ps=4.5e-06 pd=4.5e-06 m=1 region=sat
    \+1497 (vdd! 292 260 vdd!) ami06P w=9e-07 l=6e-07 as=1.71e-12 \
        ad=1.71e-12 ps=4.5e-06 pd=4.5e-06 m=1 region=sat
    \+1496 (vdd! 293 262 vdd!) ami06P w=9e-07 l=6e-07 as=1.71e-12 \
        ad=1.71e-12 ps=4.5e-06 pd=4.5e-06 m=1 region=sat
    \+1495 (vdd! 294 264 vdd!) ami06P w=9e-07 l=6e-07 as=1.71e-12 \
        ad=1.71e-12 ps=4.5e-06 pd=4.5e-06 m=1 region=sat
    \+1494 (vdd! 295 266 vdd!) ami06P w=9e-07 l=6e-07 as=1.71e-12 \
        ad=1.71e-12 ps=4.5e-06 pd=4.5e-06 m=1 region=sat
    \+1493 (vdd! 296 268 vdd!) ami06P w=9e-07 l=6e-07 as=1.71e-12 \
        ad=1.71e-12 ps=4.5e-06 pd=4.5e-06 m=1 region=sat
    \+1492 (vdd! 297 270 vdd!) ami06P w=9e-07 l=6e-07 as=1.71e-12 \
        ad=1.71e-12 ps=4.5e-06 pd=4.5e-06 m=1 region=sat
    \+1491 (vdd! 298 272 vdd!) ami06P w=9e-07 l=6e-07 as=1.71e-12 \
        ad=1.71e-12 ps=4.5e-06 pd=4.5e-06 m=1 region=sat
    \+1490 (279 226 vdd! vdd!) ami06P w=9e-07 l=6e-07 as=1.71e-12 \
        ad=1.71e-12 ps=4.5e-06 pd=4.5e-06 m=1 region=sat
    \+1489 (280 227 vdd! vdd!) ami06P w=9e-07 l=6e-07 as=1.71e-12 \
        ad=1.71e-12 ps=4.5e-06 pd=4.5e-06 m=1 region=sat
    \+1488 (281 228 vdd! vdd!) ami06P w=9e-07 l=6e-07 as=1.71e-12 \
        ad=1.71e-12 ps=4.5e-06 pd=4.5e-06 m=1 region=sat
    \+1487 (274 221 vdd! vdd!) ami06P w=9e-07 l=6e-07 as=1.71e-12 \
        ad=1.71e-12 ps=4.5e-06 pd=4.5e-06 m=1 region=sat
    \+1486 (275 222 vdd! vdd!) ami06P w=9e-07 l=6e-07 as=1.71e-12 \
        ad=1.71e-12 ps=4.5e-06 pd=4.5e-06 m=1 region=sat
    \+1485 (276 223 vdd! vdd!) ami06P w=9e-07 l=6e-07 as=1.71e-12 \
        ad=1.71e-12 ps=4.5e-06 pd=4.5e-06 m=1 region=sat
    \+1484 (277 224 vdd! vdd!) ami06P w=9e-07 l=6e-07 as=1.71e-12 \
        ad=1.71e-12 ps=4.5e-06 pd=4.5e-06 m=1 region=sat
    \+1483 (278 225 vdd! vdd!) ami06P w=9e-07 l=6e-07 as=1.71e-12 \
        ad=1.71e-12 ps=4.5e-06 pd=4.5e-06 m=1 region=sat
    \+1482 (vdd! 285 223 vdd!) ami06P w=9e-07 l=6e-07 as=1.71e-12 \
        ad=1.71e-12 ps=4.5e-06 pd=4.5e-06 m=1 region=sat
    \+1481 (vdd! 286 224 vdd!) ami06P w=9e-07 l=6e-07 as=1.71e-12 \
        ad=1.71e-12 ps=4.5e-06 pd=4.5e-06 m=1 region=sat
    \+1480 (vdd! 287 225 vdd!) ami06P w=9e-07 l=6e-07 as=1.71e-12 \
        ad=1.71e-12 ps=4.5e-06 pd=4.5e-06 m=1 region=sat
    \+1479 (vdd! 288 226 vdd!) ami06P w=9e-07 l=6e-07 as=1.71e-12 \
        ad=1.71e-12 ps=4.5e-06 pd=4.5e-06 m=1 region=sat
    \+1478 (vdd! 289 227 vdd!) ami06P w=9e-07 l=6e-07 as=1.71e-12 \
        ad=1.71e-12 ps=4.5e-06 pd=4.5e-06 m=1 region=sat
    \+1477 (vdd! 290 228 vdd!) ami06P w=9e-07 l=6e-07 as=1.71e-12 \
        ad=1.71e-12 ps=4.5e-06 pd=4.5e-06 m=1 region=sat
    \+1476 (vdd! 283 221 vdd!) ami06P w=9e-07 l=6e-07 as=1.71e-12 \
        ad=1.71e-12 ps=4.5e-06 pd=4.5e-06 m=1 region=sat
    \+1475 (vdd! 284 222 vdd!) ami06P w=9e-07 l=6e-07 as=1.71e-12 \
        ad=1.71e-12 ps=4.5e-06 pd=4.5e-06 m=1 region=sat
    \+1457 (209 193 vdd! vdd!) ami06P w=9e-07 l=6e-07 as=1.71e-12 \
        ad=1.71e-12 ps=4.5e-06 pd=4.5e-06 m=1 region=sat
    \+1456 (210 194 vdd! vdd!) ami06P w=9e-07 l=6e-07 as=1.71e-12 \
        ad=1.71e-12 ps=4.5e-06 pd=4.5e-06 m=1 region=sat
    \+1455 (211 195 vdd! vdd!) ami06P w=9e-07 l=6e-07 as=1.71e-12 \
        ad=1.71e-12 ps=4.5e-06 pd=4.5e-06 m=1 region=sat
    \+1454 (204 188 vdd! vdd!) ami06P w=9e-07 l=6e-07 as=1.71e-12 \
        ad=1.71e-12 ps=4.5e-06 pd=4.5e-06 m=1 region=sat
    \+1453 (205 189 vdd! vdd!) ami06P w=9e-07 l=6e-07 as=1.71e-12 \
        ad=1.71e-12 ps=4.5e-06 pd=4.5e-06 m=1 region=sat
    \+1452 (206 190 vdd! vdd!) ami06P w=9e-07 l=6e-07 as=1.71e-12 \
        ad=1.71e-12 ps=4.5e-06 pd=4.5e-06 m=1 region=sat
    \+1451 (207 191 vdd! vdd!) ami06P w=9e-07 l=6e-07 as=1.71e-12 \
        ad=1.71e-12 ps=4.5e-06 pd=4.5e-06 m=1 region=sat
    \+1450 (208 192 vdd! vdd!) ami06P w=9e-07 l=6e-07 as=1.71e-12 \
        ad=1.71e-12 ps=4.5e-06 pd=4.5e-06 m=1 region=sat
    \+1440 (188 221 vdd! vdd!) ami06P w=9e-07 l=6e-07 as=9.9e-13 \
        ad=1.71e-12 ps=2.1e-06 pd=4.5e-06 m=1 region=sat
    \+1439 (189 222 vdd! vdd!) ami06P w=9e-07 l=6e-07 as=9.9e-13 \
        ad=1.71e-12 ps=2.1e-06 pd=4.5e-06 m=1 region=sat
    \+1438 (190 223 vdd! vdd!) ami06P w=9e-07 l=6e-07 as=9.9e-13 \
        ad=1.71e-12 ps=2.1e-06 pd=4.5e-06 m=1 region=sat
    \+1437 (191 224 vdd! vdd!) ami06P w=9e-07 l=6e-07 as=9.9e-13 \
        ad=1.71e-12 ps=2.1e-06 pd=4.5e-06 m=1 region=sat
    \+1436 (192 225 vdd! vdd!) ami06P w=9e-07 l=6e-07 as=9.9e-13 \
        ad=1.71e-12 ps=2.1e-06 pd=4.5e-06 m=1 region=sat
    \+1435 (193 226 vdd! vdd!) ami06P w=9e-07 l=6e-07 as=9.9e-13 \
        ad=1.71e-12 ps=2.1e-06 pd=4.5e-06 m=1 region=sat
    \+1434 (194 227 vdd! vdd!) ami06P w=9e-07 l=6e-07 as=9.9e-13 \
        ad=1.71e-12 ps=2.1e-06 pd=4.5e-06 m=1 region=sat
    \+1433 (195 228 vdd! vdd!) ami06P w=9e-07 l=6e-07 as=9.9e-13 \
        ad=1.71e-12 ps=2.1e-06 pd=4.5e-06 m=1 region=sat
    \+1432 (vdd! 240 188 vdd!) ami06P w=9e-07 l=6e-07 as=1.71e-12 \
        ad=9.9e-13 ps=4.5e-06 pd=2.1e-06 m=1 region=sat
    \+1431 (vdd! 241 189 vdd!) ami06P w=9e-07 l=6e-07 as=1.71e-12 \
        ad=9.9e-13 ps=4.5e-06 pd=2.1e-06 m=1 region=sat
    \+1430 (vdd! 242 190 vdd!) ami06P w=9e-07 l=6e-07 as=1.71e-12 \
        ad=9.9e-13 ps=4.5e-06 pd=2.1e-06 m=1 region=sat
    \+1429 (vdd! 243 191 vdd!) ami06P w=9e-07 l=6e-07 as=1.71e-12 \
        ad=9.9e-13 ps=4.5e-06 pd=2.1e-06 m=1 region=sat
    \+1428 (vdd! 244 192 vdd!) ami06P w=9e-07 l=6e-07 as=1.71e-12 \
        ad=9.9e-13 ps=4.5e-06 pd=2.1e-06 m=1 region=sat
    \+1427 (vdd! 245 193 vdd!) ami06P w=9e-07 l=6e-07 as=1.71e-12 \
        ad=9.9e-13 ps=4.5e-06 pd=2.1e-06 m=1 region=sat
    \+1426 (vdd! 246 194 vdd!) ami06P w=9e-07 l=6e-07 as=1.71e-12 \
        ad=9.9e-13 ps=4.5e-06 pd=2.1e-06 m=1 region=sat
    \+1425 (vdd! 247 195 vdd!) ami06P w=9e-07 l=6e-07 as=1.71e-12 \
        ad=9.9e-13 ps=4.5e-06 pd=2.1e-06 m=1 region=sat
    \+1406 (171 154 vdd! vdd!) ami06P w=9e-07 l=6e-07 as=1.71e-12 \
        ad=1.71e-12 ps=4.5e-06 pd=4.5e-06 m=1 region=sat
    \+1405 (172 155 vdd! vdd!) ami06P w=9e-07 l=6e-07 as=1.71e-12 \
        ad=1.71e-12 ps=4.5e-06 pd=4.5e-06 m=1 region=sat
    \+1404 (173 156 vdd! vdd!) ami06P w=9e-07 l=6e-07 as=1.71e-12 \
        ad=1.71e-12 ps=4.5e-06 pd=4.5e-06 m=1 region=sat
    \+1403 (174 157 vdd! vdd!) ami06P w=9e-07 l=6e-07 as=1.71e-12 \
        ad=1.71e-12 ps=4.5e-06 pd=4.5e-06 m=1 region=sat
    \+1402 (175 158 vdd! vdd!) ami06P w=9e-07 l=6e-07 as=1.71e-12 \
        ad=1.71e-12 ps=4.5e-06 pd=4.5e-06 m=1 region=sat
    \+1401 (176 159 vdd! vdd!) ami06P w=9e-07 l=6e-07 as=1.71e-12 \
        ad=1.71e-12 ps=4.5e-06 pd=4.5e-06 m=1 region=sat
    \+1400 (177 160 vdd! vdd!) ami06P w=9e-07 l=6e-07 as=1.71e-12 \
        ad=1.71e-12 ps=4.5e-06 pd=4.5e-06 m=1 region=sat
    \+1399 (170 153 vdd! vdd!) ami06P w=9e-07 l=6e-07 as=1.71e-12 \
        ad=1.71e-12 ps=4.5e-06 pd=4.5e-06 m=1 region=sat
    \+1398 (162 145 vdd! vdd!) ami06P w=9e-07 l=6e-07 as=1.71e-12 \
        ad=1.71e-12 ps=4.5e-06 pd=4.5e-06 m=1 region=sat
    \+1397 (163 146 vdd! vdd!) ami06P w=9e-07 l=6e-07 as=1.71e-12 \
        ad=1.71e-12 ps=4.5e-06 pd=4.5e-06 m=1 region=sat
    \+1396 (164 147 vdd! vdd!) ami06P w=9e-07 l=6e-07 as=1.71e-12 \
        ad=1.71e-12 ps=4.5e-06 pd=4.5e-06 m=1 region=sat
    \+1395 (165 148 vdd! vdd!) ami06P w=9e-07 l=6e-07 as=1.71e-12 \
        ad=1.71e-12 ps=4.5e-06 pd=4.5e-06 m=1 region=sat
    \+1394 (166 149 vdd! vdd!) ami06P w=9e-07 l=6e-07 as=1.71e-12 \
        ad=1.71e-12 ps=4.5e-06 pd=4.5e-06 m=1 region=sat
    \+1393 (167 150 vdd! vdd!) ami06P w=9e-07 l=6e-07 as=1.71e-12 \
        ad=1.71e-12 ps=4.5e-06 pd=4.5e-06 m=1 region=sat
    \+1392 (168 151 vdd! vdd!) ami06P w=9e-07 l=6e-07 as=1.71e-12 \
        ad=1.71e-12 ps=4.5e-06 pd=4.5e-06 m=1 region=sat
    \+1391 (169 152 vdd! vdd!) ami06P w=9e-07 l=6e-07 as=1.71e-12 \
        ad=1.71e-12 ps=4.5e-06 pd=4.5e-06 m=1 region=sat
    \+1389 (160 228 1027 vdd!) ami06P w=9e-07 l=6e-07 as=9.9e-13 \
        ad=1.71e-12 ps=2.1e-06 pd=4.5e-06 m=1 region=sat
    \+1388 (153 221 1020 vdd!) ami06P w=9e-07 l=6e-07 as=9.9e-13 \
        ad=1.71e-12 ps=2.1e-06 pd=4.5e-06 m=1 region=sat
    \+1387 (154 222 1021 vdd!) ami06P w=9e-07 l=6e-07 as=9.9e-13 \
        ad=1.71e-12 ps=2.1e-06 pd=4.5e-06 m=1 region=sat
    \+1386 (155 223 1022 vdd!) ami06P w=9e-07 l=6e-07 as=9.9e-13 \
        ad=1.71e-12 ps=2.1e-06 pd=4.5e-06 m=1 region=sat
    \+1385 (156 224 1023 vdd!) ami06P w=9e-07 l=6e-07 as=9.9e-13 \
        ad=1.71e-12 ps=2.1e-06 pd=4.5e-06 m=1 region=sat
    \+1384 (157 225 1024 vdd!) ami06P w=9e-07 l=6e-07 as=9.9e-13 \
        ad=1.71e-12 ps=2.1e-06 pd=4.5e-06 m=1 region=sat
    \+1383 (158 226 1025 vdd!) ami06P w=9e-07 l=6e-07 as=9.9e-13 \
        ad=1.71e-12 ps=2.1e-06 pd=4.5e-06 m=1 region=sat
    \+1382 (159 227 1026 vdd!) ami06P w=9e-07 l=6e-07 as=9.9e-13 \
        ad=1.71e-12 ps=2.1e-06 pd=4.5e-06 m=1 region=sat
    \+1381 (1024 244 vdd! vdd!) ami06P w=9e-07 l=6e-07 as=1.71e-12 \
        ad=9.9e-13 ps=4.5e-06 pd=2.1e-06 m=1 region=sat
    \+1380 (1025 245 vdd! vdd!) ami06P w=9e-07 l=6e-07 as=1.71e-12 \
        ad=9.9e-13 ps=4.5e-06 pd=2.1e-06 m=1 region=sat
    \+1379 (1026 246 vdd! vdd!) ami06P w=9e-07 l=6e-07 as=1.71e-12 \
        ad=9.9e-13 ps=4.5e-06 pd=2.1e-06 m=1 region=sat
    \+1378 (1027 247 vdd! vdd!) ami06P w=9e-07 l=6e-07 as=1.71e-12 \
        ad=9.9e-13 ps=4.5e-06 pd=2.1e-06 m=1 region=sat
    \+1377 (1020 240 vdd! vdd!) ami06P w=9e-07 l=6e-07 as=1.71e-12 \
        ad=9.9e-13 ps=4.5e-06 pd=2.1e-06 m=1 region=sat
    \+1376 (1021 241 vdd! vdd!) ami06P w=9e-07 l=6e-07 as=1.71e-12 \
        ad=9.9e-13 ps=4.5e-06 pd=2.1e-06 m=1 region=sat
    \+1375 (1022 242 vdd! vdd!) ami06P w=9e-07 l=6e-07 as=1.71e-12 \
        ad=9.9e-13 ps=4.5e-06 pd=2.1e-06 m=1 region=sat
    \+1374 (1023 243 vdd! vdd!) ami06P w=9e-07 l=6e-07 as=1.71e-12 \
        ad=9.9e-13 ps=4.5e-06 pd=2.1e-06 m=1 region=sat
    \+1365 (145 120 613 vdd!) ami06P w=9e-07 l=6e-07 as=1.71e-12 \
        ad=1.71e-12 ps=4.5e-06 pd=4.5e-06 m=1 region=sat
    \+1364 (146 121 614 vdd!) ami06P w=9e-07 l=6e-07 as=1.71e-12 \
        ad=1.71e-12 ps=4.5e-06 pd=4.5e-06 m=1 region=sat
    \+1363 (147 122 615 vdd!) ami06P w=9e-07 l=6e-07 as=1.71e-12 \
        ad=1.71e-12 ps=4.5e-06 pd=4.5e-06 m=1 region=sat
    \+1362 (148 123 616 vdd!) ami06P w=9e-07 l=6e-07 as=1.71e-12 \
        ad=1.71e-12 ps=4.5e-06 pd=4.5e-06 m=1 region=sat
    \+1361 (149 124 617 vdd!) ami06P w=9e-07 l=6e-07 as=1.71e-12 \
        ad=1.71e-12 ps=4.5e-06 pd=4.5e-06 m=1 region=sat
    \+1360 (150 125 618 vdd!) ami06P w=9e-07 l=6e-07 as=1.71e-12 \
        ad=1.71e-12 ps=4.5e-06 pd=4.5e-06 m=1 region=sat
    \+1359 (151 126 619 vdd!) ami06P w=9e-07 l=6e-07 as=1.71e-12 \
        ad=1.71e-12 ps=4.5e-06 pd=4.5e-06 m=1 region=sat
    \+1358 (152 127 620 vdd!) ami06P w=9e-07 l=6e-07 as=1.71e-12 \
        ad=1.71e-12 ps=4.5e-06 pd=4.5e-06 m=1 region=sat
    \+1335 (57 99 vdd! vdd!) ami06P w=9e-07 l=6e-07 as=1.71e-12 \
        ad=1.71e-12 ps=4.5e-06 pd=4.5e-06 m=1 region=sat
    \+1334 (59 100 vdd! vdd!) ami06P w=9e-07 l=6e-07 as=1.71e-12 \
        ad=1.71e-12 ps=4.5e-06 pd=4.5e-06 m=1 region=sat
    \+1333 (45 93 vdd! vdd!) ami06P w=9e-07 l=6e-07 as=1.71e-12 \
        ad=1.71e-12 ps=4.5e-06 pd=4.5e-06 m=1 region=sat
    \+1332 (47 94 vdd! vdd!) ami06P w=9e-07 l=6e-07 as=1.71e-12 \
        ad=1.71e-12 ps=4.5e-06 pd=4.5e-06 m=1 region=sat
    \+1331 (49 95 vdd! vdd!) ami06P w=9e-07 l=6e-07 as=1.71e-12 \
        ad=1.71e-12 ps=4.5e-06 pd=4.5e-06 m=1 region=sat
    \+1330 (51 96 vdd! vdd!) ami06P w=9e-07 l=6e-07 as=1.71e-12 \
        ad=1.71e-12 ps=4.5e-06 pd=4.5e-06 m=1 region=sat
    \+1329 (53 97 vdd! vdd!) ami06P w=9e-07 l=6e-07 as=1.71e-12 \
        ad=1.71e-12 ps=4.5e-06 pd=4.5e-06 m=1 region=sat
    \+1328 (55 98 vdd! vdd!) ami06P w=9e-07 l=6e-07 as=1.71e-12 \
        ad=1.71e-12 ps=4.5e-06 pd=4.5e-06 m=1 region=sat
    \+1327 (vdd! 51 104 vdd!) ami06P w=9e-07 l=6e-07 as=1.71e-12 \
        ad=1.71e-12 ps=4.5e-06 pd=4.5e-06 m=1 region=sat
    \+1326 (vdd! 53 105 vdd!) ami06P w=9e-07 l=6e-07 as=1.71e-12 \
        ad=1.71e-12 ps=4.5e-06 pd=4.5e-06 m=1 region=sat
    \+1325 (vdd! 55 106 vdd!) ami06P w=9e-07 l=6e-07 as=1.71e-12 \
        ad=1.71e-12 ps=4.5e-06 pd=4.5e-06 m=1 region=sat
    \+1324 (vdd! 57 107 vdd!) ami06P w=9e-07 l=6e-07 as=1.71e-12 \
        ad=1.71e-12 ps=4.5e-06 pd=4.5e-06 m=1 region=sat
    \+1323 (vdd! 59 108 vdd!) ami06P w=9e-07 l=6e-07 as=1.71e-12 \
        ad=1.71e-12 ps=4.5e-06 pd=4.5e-06 m=1 region=sat
    \+1322 (vdd! 45 101 vdd!) ami06P w=9e-07 l=6e-07 as=1.71e-12 \
        ad=1.71e-12 ps=4.5e-06 pd=4.5e-06 m=1 region=sat
    \+1321 (vdd! 47 102 vdd!) ami06P w=9e-07 l=6e-07 as=1.71e-12 \
        ad=1.71e-12 ps=4.5e-06 pd=4.5e-06 m=1 region=sat
    \+1320 (vdd! 49 103 vdd!) ami06P w=9e-07 l=6e-07 as=1.71e-12 \
        ad=1.71e-12 ps=4.5e-06 pd=4.5e-06 m=1 region=sat
    \+1319 (85 70 vdd! vdd!) ami06P w=9e-07 l=6e-07 as=1.71e-12 \
        ad=1.71e-12 ps=4.5e-06 pd=4.5e-06 m=1 region=sat
    \+1318 (86 72 vdd! vdd!) ami06P w=9e-07 l=6e-07 as=1.71e-12 \
        ad=1.71e-12 ps=4.5e-06 pd=4.5e-06 m=1 region=sat
    \+1317 (87 74 vdd! vdd!) ami06P w=9e-07 l=6e-07 as=1.71e-12 \
        ad=1.71e-12 ps=4.5e-06 pd=4.5e-06 m=1 region=sat
    \+1316 (88 76 vdd! vdd!) ami06P w=9e-07 l=6e-07 as=1.71e-12 \
        ad=1.71e-12 ps=4.5e-06 pd=4.5e-06 m=1 region=sat
    \+1315 (89 78 vdd! vdd!) ami06P w=9e-07 l=6e-07 as=1.71e-12 \
        ad=1.71e-12 ps=4.5e-06 pd=4.5e-06 m=1 region=sat
    \+1314 (90 80 vdd! vdd!) ami06P w=9e-07 l=6e-07 as=1.71e-12 \
        ad=1.71e-12 ps=4.5e-06 pd=4.5e-06 m=1 region=sat
    \+1313 (91 82 vdd! vdd!) ami06P w=9e-07 l=6e-07 as=1.71e-12 \
        ad=1.71e-12 ps=4.5e-06 pd=4.5e-06 m=1 region=sat
    \+1312 (92 84 vdd! vdd!) ami06P w=9e-07 l=6e-07 as=1.71e-12 \
        ad=1.71e-12 ps=4.5e-06 pd=4.5e-06 m=1 region=sat
    \+1311 (vdd! 85 69 vdd!) ami06P w=9e-07 l=6e-07 as=1.71e-12 \
        ad=1.71e-12 ps=4.5e-06 pd=4.5e-06 m=1 region=sat
    \+1310 (vdd! 86 71 vdd!) ami06P w=9e-07 l=6e-07 as=1.71e-12 \
        ad=1.71e-12 ps=4.5e-06 pd=4.5e-06 m=1 region=sat
    \+1309 (vdd! 87 73 vdd!) ami06P w=9e-07 l=6e-07 as=1.71e-12 \
        ad=1.71e-12 ps=4.5e-06 pd=4.5e-06 m=1 region=sat
    \+1308 (vdd! 88 75 vdd!) ami06P w=9e-07 l=6e-07 as=1.71e-12 \
        ad=1.71e-12 ps=4.5e-06 pd=4.5e-06 m=1 region=sat
    \+1307 (vdd! 89 77 vdd!) ami06P w=9e-07 l=6e-07 as=1.71e-12 \
        ad=1.71e-12 ps=4.5e-06 pd=4.5e-06 m=1 region=sat
    \+1306 (vdd! 90 79 vdd!) ami06P w=9e-07 l=6e-07 as=1.71e-12 \
        ad=1.71e-12 ps=4.5e-06 pd=4.5e-06 m=1 region=sat
    \+1305 (vdd! 91 81 vdd!) ami06P w=9e-07 l=6e-07 as=1.71e-12 \
        ad=1.71e-12 ps=4.5e-06 pd=4.5e-06 m=1 region=sat
    \+1304 (vdd! 92 83 vdd!) ami06P w=9e-07 l=6e-07 as=1.71e-12 \
        ad=1.71e-12 ps=4.5e-06 pd=4.5e-06 m=1 region=sat
    \+1734 (594 561 1028 vdd!) ami06P w=9e-07 l=6e-07 as=9.9e-13 \
        ad=1.71e-12 ps=2.1e-06 pd=4.5e-06 m=1 region=sat
    \+1733 (595 563 1029 vdd!) ami06P w=9e-07 l=6e-07 as=9.9e-13 \
        ad=1.71e-12 ps=2.1e-06 pd=4.5e-06 m=1 region=sat
    \+1732 (596 565 1030 vdd!) ami06P w=9e-07 l=6e-07 as=9.9e-13 \
        ad=1.71e-12 ps=2.1e-06 pd=4.5e-06 m=1 region=sat
    \+1731 (597 567 1031 vdd!) ami06P w=9e-07 l=6e-07 as=9.9e-13 \
        ad=1.71e-12 ps=2.1e-06 pd=4.5e-06 m=1 region=sat
    \+1730 (1028 560 vdd! vdd!) ami06P w=9e-07 l=6e-07 as=1.71e-12 \
        ad=9.9e-13 ps=4.5e-06 pd=2.1e-06 m=1 region=sat
    \+1729 (1029 562 vdd! vdd!) ami06P w=9e-07 l=6e-07 as=1.71e-12 \
        ad=9.9e-13 ps=4.5e-06 pd=2.1e-06 m=1 region=sat
    \+1728 (1030 564 vdd! vdd!) ami06P w=9e-07 l=6e-07 as=1.71e-12 \
        ad=9.9e-13 ps=4.5e-06 pd=2.1e-06 m=1 region=sat
    \+1727 (1031 566 vdd! vdd!) ami06P w=9e-07 l=6e-07 as=1.71e-12 \
        ad=9.9e-13 ps=4.5e-06 pd=2.1e-06 m=1 region=sat
    \+1559 (vdd! Memory\<0\> 348 vdd!) ami06P w=9e-07 l=6e-07 as=1.71e-12 \
        ad=1.71e-12 ps=4.5e-06 pd=4.5e-06 m=1 region=sat
    \+1541 (vdd! 348 331 vdd!) ami06P w=9e-07 l=6e-07 as=1.71e-12 \
        ad=1.71e-12 ps=4.5e-06 pd=4.5e-06 m=1 region=sat
    \+1508 (vdd! Memory\<1\> 282 vdd!) ami06P w=9e-07 l=6e-07 as=1.71e-12 \
        ad=1.71e-12 ps=4.5e-06 pd=4.5e-06 m=1 region=sat
    \+1474 (vdd! 282 257 vdd!) ami06P w=9e-07 l=6e-07 as=1.71e-12 \
        ad=1.71e-12 ps=4.5e-06 pd=4.5e-06 m=1 region=sat
    \+1473 (vdd! Memory\<2\> 248 vdd!) ami06P w=9e-07 l=6e-07 as=1.71e-12 \
        ad=1.71e-12 ps=4.5e-06 pd=4.5e-06 m=1 region=sat
    \+1471 (vdd! 248 239 vdd!) ami06P w=9e-07 l=6e-07 as=1.71e-12 \
        ad=1.71e-12 ps=4.5e-06 pd=4.5e-06 m=1 region=sat
    \+1470 (vdd! Memory\<3\> 238 vdd!) ami06P w=9e-07 l=6e-07 as=1.71e-12 \
        ad=1.71e-12 ps=4.5e-06 pd=4.5e-06 m=1 region=sat
    \+1468 (vdd! 238 229 vdd!) ami06P w=9e-07 l=6e-07 as=1.71e-12 \
        ad=1.71e-12 ps=4.5e-06 pd=4.5e-06 m=1 region=sat
    \+1467 (vdd! Memory\<4\> 212 vdd!) ami06P w=9e-07 l=6e-07 as=1.71e-12 \
        ad=1.71e-12 ps=4.5e-06 pd=4.5e-06 m=1 region=sat
    \+1465 (vdd! 221 213 vdd!) ami06P w=9e-07 l=6e-07 as=1.71e-12 \
        ad=1.71e-12 ps=4.5e-06 pd=4.5e-06 m=1 region=sat
    \+1464 (vdd! 222 214 vdd!) ami06P w=9e-07 l=6e-07 as=1.71e-12 \
        ad=1.71e-12 ps=4.5e-06 pd=4.5e-06 m=1 region=sat
    \+1463 (vdd! 223 215 vdd!) ami06P w=9e-07 l=6e-07 as=1.71e-12 \
        ad=1.71e-12 ps=4.5e-06 pd=4.5e-06 m=1 region=sat
    \+1462 (vdd! 224 216 vdd!) ami06P w=9e-07 l=6e-07 as=1.71e-12 \
        ad=1.71e-12 ps=4.5e-06 pd=4.5e-06 m=1 region=sat
    \+1461 (vdd! 225 217 vdd!) ami06P w=9e-07 l=6e-07 as=1.71e-12 \
        ad=1.71e-12 ps=4.5e-06 pd=4.5e-06 m=1 region=sat
    \+1460 (vdd! 226 218 vdd!) ami06P w=9e-07 l=6e-07 as=1.71e-12 \
        ad=1.71e-12 ps=4.5e-06 pd=4.5e-06 m=1 region=sat
    \+1459 (vdd! 227 219 vdd!) ami06P w=9e-07 l=6e-07 as=1.71e-12 \
        ad=1.71e-12 ps=4.5e-06 pd=4.5e-06 m=1 region=sat
    \+1458 (vdd! 228 220 vdd!) ami06P w=9e-07 l=6e-07 as=1.71e-12 \
        ad=1.71e-12 ps=4.5e-06 pd=4.5e-06 m=1 region=sat
    \+1441 (vdd! 212 179 vdd!) ami06P w=9e-07 l=6e-07 as=1.71e-12 \
        ad=1.71e-12 ps=4.5e-06 pd=4.5e-06 m=1 region=sat
    \+1424 (vdd! 245 185 vdd!) ami06P w=9e-07 l=6e-07 as=1.71e-12 \
        ad=1.71e-12 ps=4.5e-06 pd=4.5e-06 m=1 region=sat
    \+1423 (vdd! 246 186 vdd!) ami06P w=9e-07 l=6e-07 as=1.71e-12 \
        ad=1.71e-12 ps=4.5e-06 pd=4.5e-06 m=1 region=sat
    \+1422 (vdd! 247 187 vdd!) ami06P w=9e-07 l=6e-07 as=1.71e-12 \
        ad=1.71e-12 ps=4.5e-06 pd=4.5e-06 m=1 region=sat
    \+1421 (vdd! 240 180 vdd!) ami06P w=9e-07 l=6e-07 as=1.71e-12 \
        ad=1.71e-12 ps=4.5e-06 pd=4.5e-06 m=1 region=sat
    \+1420 (vdd! 241 181 vdd!) ami06P w=9e-07 l=6e-07 as=1.71e-12 \
        ad=1.71e-12 ps=4.5e-06 pd=4.5e-06 m=1 region=sat
    \+1419 (vdd! 242 182 vdd!) ami06P w=9e-07 l=6e-07 as=1.71e-12 \
        ad=1.71e-12 ps=4.5e-06 pd=4.5e-06 m=1 region=sat
    \+1418 (vdd! 243 183 vdd!) ami06P w=9e-07 l=6e-07 as=1.71e-12 \
        ad=1.71e-12 ps=4.5e-06 pd=4.5e-06 m=1 region=sat
    \+1417 (vdd! 244 184 vdd!) ami06P w=9e-07 l=6e-07 as=1.71e-12 \
        ad=1.71e-12 ps=4.5e-06 pd=4.5e-06 m=1 region=sat
    \+1416 (vdd! Memory\<5\> 178 vdd!) ami06P w=9e-07 l=6e-07 as=1.71e-12 \
        ad=1.71e-12 ps=4.5e-06 pd=4.5e-06 m=1 region=sat
    \+1390 (vdd! 178 161 vdd!) ami06P w=9e-07 l=6e-07 as=1.71e-12 \
        ad=1.71e-12 ps=4.5e-06 pd=4.5e-06 m=1 region=sat
    \+1357 (vdd! Memory\<6\> 136 vdd!) ami06P w=9e-07 l=6e-07 as=1.71e-12 \
        ad=1.71e-12 ps=4.5e-06 pd=4.5e-06 m=1 region=sat
    \+1355 (137 120 vdd! vdd!) ami06P w=9e-07 l=6e-07 as=1.71e-12 \
        ad=1.71e-12 ps=4.5e-06 pd=4.5e-06 m=1 region=sat
    \+1354 (138 121 vdd! vdd!) ami06P w=9e-07 l=6e-07 as=1.71e-12 \
        ad=1.71e-12 ps=4.5e-06 pd=4.5e-06 m=1 region=sat
    \+1353 (139 122 vdd! vdd!) ami06P w=9e-07 l=6e-07 as=1.71e-12 \
        ad=1.71e-12 ps=4.5e-06 pd=4.5e-06 m=1 region=sat
    \+1352 (140 123 vdd! vdd!) ami06P w=9e-07 l=6e-07 as=1.71e-12 \
        ad=1.71e-12 ps=4.5e-06 pd=4.5e-06 m=1 region=sat
    \+1351 (141 124 vdd! vdd!) ami06P w=9e-07 l=6e-07 as=1.71e-12 \
        ad=1.71e-12 ps=4.5e-06 pd=4.5e-06 m=1 region=sat
    \+1350 (142 125 vdd! vdd!) ami06P w=9e-07 l=6e-07 as=1.71e-12 \
        ad=1.71e-12 ps=4.5e-06 pd=4.5e-06 m=1 region=sat
    \+1349 (143 126 vdd! vdd!) ami06P w=9e-07 l=6e-07 as=1.71e-12 \
        ad=1.71e-12 ps=4.5e-06 pd=4.5e-06 m=1 region=sat
    \+1348 (144 127 vdd! vdd!) ami06P w=9e-07 l=6e-07 as=1.71e-12 \
        ad=1.71e-12 ps=4.5e-06 pd=4.5e-06 m=1 region=sat
    \+1347 (vdd! 136 119 vdd!) ami06P w=9e-07 l=6e-07 as=1.71e-12 \
        ad=1.71e-12 ps=4.5e-06 pd=4.5e-06 m=1 region=sat
    \+1338 (vdd! Memory\<7\> 110 vdd!) ami06P w=9e-07 l=6e-07 as=1.71e-12 \
        ad=1.71e-12 ps=4.5e-06 pd=4.5e-06 m=1 region=sat
    \+1336 (vdd! 110 109 vdd!) ami06P w=9e-07 l=6e-07 as=1.71e-12 \
        ad=1.71e-12 ps=4.5e-06 pd=4.5e-06 m=1 region=sat
    \+1710 (382 44 vdd! vdd!) ami06P w=9e-07 l=1.95e-06 as=1.98e-12 \
        ad=1.71e-12 ps=5.1e-06 pd=4.5e-06 m=1 region=sat
    \+1709 (384 44 vdd! vdd!) ami06P w=9e-07 l=1.95e-06 as=1.98e-12 \
        ad=1.71e-12 ps=5.1e-06 pd=4.5e-06 m=1 region=sat
    \+1708 (386 44 vdd! vdd!) ami06P w=9e-07 l=1.95e-06 as=1.98e-12 \
        ad=1.71e-12 ps=5.1e-06 pd=4.5e-06 m=1 region=sat
    \+1707 (388 44 vdd! vdd!) ami06P w=9e-07 l=1.95e-06 as=1.98e-12 \
        ad=1.71e-12 ps=5.1e-06 pd=4.5e-06 m=1 region=sat
    \+1706 (390 44 vdd! vdd!) ami06P w=9e-07 l=1.95e-06 as=1.98e-12 \
        ad=1.71e-12 ps=5.1e-06 pd=4.5e-06 m=1 region=sat
    \+1558 (331 F2 Memory\<0\> vdd!) ami06P w=2.7e-06 l=6e-07 as=4.05e-12 \
        ad=4.05e-12 ps=5.7e-06 pd=5.7e-06 m=1 region=sat
    \+1507 (257 F2 Memory\<1\> vdd!) ami06P w=2.7e-06 l=6e-07 as=4.05e-12 \
        ad=4.05e-12 ps=5.7e-06 pd=5.7e-06 m=1 region=sat
    \+1472 (239 F2 Memory\<2\> vdd!) ami06P w=2.7e-06 l=6e-07 as=4.05e-12 \
        ad=4.05e-12 ps=5.7e-06 pd=5.7e-06 m=1 region=sat
    \+1469 (229 F2 Memory\<3\> vdd!) ami06P w=2.7e-06 l=6e-07 as=4.05e-12 \
        ad=4.05e-12 ps=5.7e-06 pd=5.7e-06 m=1 region=sat
    \+1466 (179 F2 Memory\<4\> vdd!) ami06P w=2.7e-06 l=6e-07 as=4.05e-12 \
        ad=4.05e-12 ps=5.7e-06 pd=5.7e-06 m=1 region=sat
    \+1415 (161 F2 Memory\<5\> vdd!) ami06P w=2.7e-06 l=6e-07 as=4.05e-12 \
        ad=4.05e-12 ps=5.7e-06 pd=5.7e-06 m=1 region=sat
    \+1356 (119 F2 Memory\<6\> vdd!) ami06P w=2.7e-06 l=6e-07 as=4.05e-12 \
        ad=4.05e-12 ps=5.7e-06 pd=5.7e-06 m=1 region=sat
    \+1337 (109 F2 Memory\<7\> vdd!) ami06P w=2.7e-06 l=6e-07 as=4.05e-12 \
        ad=4.05e-12 ps=5.7e-06 pd=5.7e-06 m=1 region=sat
    \+1449 (198 44 vdd! vdd!) ami06P w=9e-07 l=1.95e-06 as=1.98e-12 \
        ad=1.71e-12 ps=5.1e-06 pd=4.5e-06 m=1 region=sat
    \+1448 (199 44 vdd! vdd!) ami06P w=9e-07 l=1.95e-06 as=1.98e-12 \
        ad=1.71e-12 ps=5.1e-06 pd=4.5e-06 m=1 region=sat
    \+1447 (200 44 vdd! vdd!) ami06P w=9e-07 l=1.95e-06 as=1.98e-12 \
        ad=1.71e-12 ps=5.1e-06 pd=4.5e-06 m=1 region=sat
    \+1446 (201 44 vdd! vdd!) ami06P w=9e-07 l=1.95e-06 as=1.98e-12 \
        ad=1.71e-12 ps=5.1e-06 pd=4.5e-06 m=1 region=sat
    \+1445 (202 44 vdd! vdd!) ami06P w=9e-07 l=1.95e-06 as=1.98e-12 \
        ad=1.71e-12 ps=5.1e-06 pd=4.5e-06 m=1 region=sat
    \+1444 (203 44 vdd! vdd!) ami06P w=9e-07 l=1.95e-06 as=1.98e-12 \
        ad=1.71e-12 ps=5.1e-06 pd=4.5e-06 m=1 region=sat
    \+1443 (196 44 vdd! vdd!) ami06P w=9e-07 l=1.95e-06 as=1.98e-12 \
        ad=1.71e-12 ps=5.1e-06 pd=4.5e-06 m=1 region=sat
    \+1442 (197 44 vdd! vdd!) ami06P w=9e-07 l=1.95e-06 as=1.98e-12 \
        ad=1.71e-12 ps=5.1e-06 pd=4.5e-06 m=1 region=sat
    \+1414 (149 44 617 vdd!) ami06P w=9e-07 l=1.2e-06 as=2.385e-12 \
        ad=1.98e-12 ps=6e-06 pd=5.1e-06 m=1 region=sat
    \+1413 (150 44 618 vdd!) ami06P w=9e-07 l=1.2e-06 as=2.385e-12 \
        ad=1.98e-12 ps=6e-06 pd=5.1e-06 m=1 region=sat
    \+1412 (151 44 619 vdd!) ami06P w=9e-07 l=1.2e-06 as=2.385e-12 \
        ad=1.98e-12 ps=6e-06 pd=5.1e-06 m=1 region=sat
    \+1411 (152 44 620 vdd!) ami06P w=9e-07 l=1.2e-06 as=2.385e-12 \
        ad=1.98e-12 ps=6e-06 pd=5.1e-06 m=1 region=sat
    \+1410 (145 44 613 vdd!) ami06P w=9e-07 l=1.2e-06 as=2.385e-12 \
        ad=1.98e-12 ps=6e-06 pd=5.1e-06 m=1 region=sat
    \+1409 (146 44 614 vdd!) ami06P w=9e-07 l=1.2e-06 as=2.385e-12 \
        ad=1.98e-12 ps=6e-06 pd=5.1e-06 m=1 region=sat
    \+1408 (147 44 615 vdd!) ami06P w=9e-07 l=1.2e-06 as=2.385e-12 \
        ad=1.98e-12 ps=6e-06 pd=5.1e-06 m=1 region=sat
    \+1407 (148 44 616 vdd!) ami06P w=9e-07 l=1.2e-06 as=2.385e-12 \
        ad=1.98e-12 ps=6e-06 pd=5.1e-06 m=1 region=sat
    \+1373 (614 44 vdd! vdd!) ami06P w=9e-07 l=1.2e-06 as=2.115e-12 \
        ad=2.25e-12 ps=5.4e-06 pd=5.7e-06 m=1 region=sat
    \+1372 (615 44 vdd! vdd!) ami06P w=9e-07 l=1.2e-06 as=2.115e-12 \
        ad=2.25e-12 ps=5.4e-06 pd=5.7e-06 m=1 region=sat
    \+1371 (616 44 vdd! vdd!) ami06P w=9e-07 l=1.2e-06 as=2.115e-12 \
        ad=2.25e-12 ps=5.4e-06 pd=5.7e-06 m=1 region=sat
    \+1370 (617 44 vdd! vdd!) ami06P w=9e-07 l=1.2e-06 as=2.115e-12 \
        ad=2.25e-12 ps=5.4e-06 pd=5.7e-06 m=1 region=sat
    \+1369 (618 44 vdd! vdd!) ami06P w=9e-07 l=1.2e-06 as=2.115e-12 \
        ad=2.25e-12 ps=5.4e-06 pd=5.7e-06 m=1 region=sat
    \+1368 (619 44 vdd! vdd!) ami06P w=9e-07 l=1.2e-06 as=2.115e-12 \
        ad=2.25e-12 ps=5.4e-06 pd=5.7e-06 m=1 region=sat
    \+1367 (620 44 vdd! vdd!) ami06P w=9e-07 l=1.2e-06 as=2.115e-12 \
        ad=2.25e-12 ps=5.4e-06 pd=5.7e-06 m=1 region=sat
    \+1366 (613 44 vdd! vdd!) ami06P w=9e-07 l=1.2e-06 as=2.115e-12 \
        ad=2.25e-12 ps=5.4e-06 pd=5.7e-06 m=1 region=sat
    \+1346 (vdd! 44 126 vdd!) ami06P w=9e-07 l=1.2e-06 as=2.25e-12 \
        ad=2.115e-12 ps=5.7e-06 pd=5.4e-06 m=1 region=sat
    \+1345 (vdd! 44 127 vdd!) ami06P w=9e-07 l=1.2e-06 as=2.25e-12 \
        ad=2.115e-12 ps=5.7e-06 pd=5.4e-06 m=1 region=sat
    \+1344 (vdd! 44 120 vdd!) ami06P w=9e-07 l=1.2e-06 as=2.25e-12 \
        ad=2.115e-12 ps=5.7e-06 pd=5.4e-06 m=1 region=sat
    \+1343 (vdd! 44 121 vdd!) ami06P w=9e-07 l=1.2e-06 as=2.25e-12 \
        ad=2.115e-12 ps=5.7e-06 pd=5.4e-06 m=1 region=sat
    \+1342 (vdd! 44 122 vdd!) ami06P w=9e-07 l=1.2e-06 as=2.25e-12 \
        ad=2.115e-12 ps=5.7e-06 pd=5.4e-06 m=1 region=sat
    \+1341 (vdd! 44 123 vdd!) ami06P w=9e-07 l=1.2e-06 as=2.25e-12 \
        ad=2.115e-12 ps=5.7e-06 pd=5.4e-06 m=1 region=sat
    \+1340 (vdd! 44 124 vdd!) ami06P w=9e-07 l=1.2e-06 as=2.25e-12 \
        ad=2.115e-12 ps=5.7e-06 pd=5.4e-06 m=1 region=sat
    \+1339 (vdd! 44 125 vdd!) ami06P w=9e-07 l=1.2e-06 as=2.25e-12 \
        ad=2.115e-12 ps=5.7e-06 pd=5.4e-06 m=1 region=sat
ends bus_top
// End of subcircuit definition.

// Library name: cse463_project
// Cell name: IR_reg
// View name: extracted
subckt IR_reg Control_Out0 Control_Out1 Control_Out5 Control_Out6 \
        Control_Out7 F1 F2 In\<0\> In\<1\> In\<2\> In\<3\> In\<4\> In\<5\> \
        In\<6\> In\<7\> N0 N0B N1 N1B Out\<0\> Out\<1\> Out\<2\> Out\<3\> \
        Out\<4\> Out\<5\> Out\<6\> Out\<7\> S0 S0B S1 S1B
    \+207 (Out\<1\> N0 102 32) ami06P w=1.8e-06 l=6e-07 as=1.62e-12 \
        ad=2.7e-12 ps=1.8e-06 pd=4.8e-06 m=1 region=sat
    \+206 (Out\<2\> N0 103 32) ami06P w=1.8e-06 l=6e-07 as=1.62e-12 \
        ad=2.7e-12 ps=1.8e-06 pd=4.8e-06 m=1 region=sat
    \+205 (Out\<3\> N0 104 32) ami06P w=1.8e-06 l=6e-07 as=1.62e-12 \
        ad=2.7e-12 ps=1.8e-06 pd=4.8e-06 m=1 region=sat
    \+204 (Out\<4\> N0 105 32) ami06P w=1.8e-06 l=6e-07 as=1.62e-12 \
        ad=2.7e-12 ps=1.8e-06 pd=4.8e-06 m=1 region=sat
    \+203 (Out\<5\> N0 106 32) ami06P w=1.8e-06 l=6e-07 as=1.62e-12 \
        ad=2.7e-12 ps=1.8e-06 pd=4.8e-06 m=1 region=sat
    \+202 (Out\<6\> N0 107 32) ami06P w=1.8e-06 l=6e-07 as=1.62e-12 \
        ad=2.7e-12 ps=1.8e-06 pd=4.8e-06 m=1 region=sat
    \+201 (Out\<7\> N0 108 32) ami06P w=1.8e-06 l=6e-07 as=1.62e-12 \
        ad=2.7e-12 ps=1.8e-06 pd=4.8e-06 m=1 region=sat
    \+200 (Out\<0\> N0 101 32) ami06P w=1.8e-06 l=6e-07 as=1.62e-12 \
        ad=2.7e-12 ps=1.8e-06 pd=4.8e-06 m=1 region=sat
    \+199 (101 N1 86 32) ami06P w=1.8e-06 l=6e-07 as=2.7e-12 ad=1.62e-12 \
        ps=4.8e-06 pd=1.8e-06 m=1 region=sat
    \+198 (102 N1 88 32) ami06P w=1.8e-06 l=6e-07 as=2.7e-12 ad=1.62e-12 \
        ps=4.8e-06 pd=1.8e-06 m=1 region=sat
    \+197 (103 N1 90 32) ami06P w=1.8e-06 l=6e-07 as=2.7e-12 ad=1.62e-12 \
        ps=4.8e-06 pd=1.8e-06 m=1 region=sat
    \+196 (104 N1 92 32) ami06P w=1.8e-06 l=6e-07 as=2.7e-12 ad=1.62e-12 \
        ps=4.8e-06 pd=1.8e-06 m=1 region=sat
    \+195 (105 N1 94 32) ami06P w=1.8e-06 l=6e-07 as=2.7e-12 ad=1.62e-12 \
        ps=4.8e-06 pd=1.8e-06 m=1 region=sat
    \+194 (106 N1 96 32) ami06P w=1.8e-06 l=6e-07 as=2.7e-12 ad=1.62e-12 \
        ps=4.8e-06 pd=1.8e-06 m=1 region=sat
    \+193 (107 N1 98 32) ami06P w=1.8e-06 l=6e-07 as=2.7e-12 ad=1.62e-12 \
        ps=4.8e-06 pd=1.8e-06 m=1 region=sat
    \+192 (108 N1 100 32) ami06P w=1.8e-06 l=6e-07 as=2.7e-12 ad=1.62e-12 \
        ps=4.8e-06 pd=1.8e-06 m=1 region=sat
    \+143 (Out\<0\> N0B 101 33) ami06N w=1.8e-06 l=6e-07 as=1.62e-12 \
        ad=2.7e-12 ps=1.8e-06 pd=4.8e-06 m=1 region=sat
    \+142 (Out\<1\> N0B 102 33) ami06N w=1.8e-06 l=6e-07 as=1.62e-12 \
        ad=2.7e-12 ps=1.8e-06 pd=4.8e-06 m=1 region=sat
    \+141 (Out\<2\> N0B 103 33) ami06N w=1.8e-06 l=6e-07 as=1.62e-12 \
        ad=2.7e-12 ps=1.8e-06 pd=4.8e-06 m=1 region=sat
    \+140 (Out\<3\> N0B 104 33) ami06N w=1.8e-06 l=6e-07 as=1.62e-12 \
        ad=2.7e-12 ps=1.8e-06 pd=4.8e-06 m=1 region=sat
    \+139 (Out\<4\> N0B 105 33) ami06N w=1.8e-06 l=6e-07 as=1.62e-12 \
        ad=2.7e-12 ps=1.8e-06 pd=4.8e-06 m=1 region=sat
    \+138 (Out\<5\> N0B 106 33) ami06N w=1.8e-06 l=6e-07 as=1.62e-12 \
        ad=2.7e-12 ps=1.8e-06 pd=4.8e-06 m=1 region=sat
    \+137 (Out\<6\> N0B 107 33) ami06N w=1.8e-06 l=6e-07 as=1.62e-12 \
        ad=2.7e-12 ps=1.8e-06 pd=4.8e-06 m=1 region=sat
    \+136 (Out\<7\> N0B 108 33) ami06N w=1.8e-06 l=6e-07 as=1.62e-12 \
        ad=2.7e-12 ps=1.8e-06 pd=4.8e-06 m=1 region=sat
    \+135 (101 N1B 86 33) ami06N w=1.8e-06 l=6e-07 as=2.7e-12 ad=1.62e-12 \
        ps=4.8e-06 pd=1.8e-06 m=1 region=sat
    \+134 (102 N1B 88 33) ami06N w=1.8e-06 l=6e-07 as=2.7e-12 ad=1.62e-12 \
        ps=4.8e-06 pd=1.8e-06 m=1 region=sat
    \+133 (103 N1B 90 33) ami06N w=1.8e-06 l=6e-07 as=2.7e-12 ad=1.62e-12 \
        ps=4.8e-06 pd=1.8e-06 m=1 region=sat
    \+132 (104 N1B 92 33) ami06N w=1.8e-06 l=6e-07 as=2.7e-12 ad=1.62e-12 \
        ps=4.8e-06 pd=1.8e-06 m=1 region=sat
    \+131 (105 N1B 94 33) ami06N w=1.8e-06 l=6e-07 as=2.7e-12 ad=1.62e-12 \
        ps=4.8e-06 pd=1.8e-06 m=1 region=sat
    \+130 (106 N1B 96 33) ami06N w=1.8e-06 l=6e-07 as=2.7e-12 ad=1.62e-12 \
        ps=4.8e-06 pd=1.8e-06 m=1 region=sat
    \+129 (107 N1B 98 33) ami06N w=1.8e-06 l=6e-07 as=2.7e-12 ad=1.62e-12 \
        ps=4.8e-06 pd=1.8e-06 m=1 region=sat
    \+128 (108 N1B 100 33) ami06N w=1.8e-06 l=6e-07 as=2.7e-12 ad=1.62e-12 \
        ps=4.8e-06 pd=1.8e-06 m=1 region=sat
    \+127 (87 Control_Out1 33 33) ami06N w=9e-07 l=6e-07 as=1.71e-12 \
        ad=1.71e-12 ps=4.5e-06 pd=4.5e-06 m=1 region=sat
    \+126 (98 97 33 33) ami06N w=9e-07 l=6e-07 as=1.71e-12 ad=1.71e-12 \
        ps=4.5e-06 pd=4.5e-06 m=1 region=sat
    \+125 (88 87 33 33) ami06N w=9e-07 l=6e-07 as=1.71e-12 ad=1.71e-12 \
        ps=4.5e-06 pd=4.5e-06 m=1 region=sat
    \+124 (99 Control_Out7 33 33) ami06N w=9e-07 l=6e-07 as=1.71e-12 \
        ad=1.71e-12 ps=4.5e-06 pd=4.5e-06 m=1 region=sat
    \+123 (89 34 33 33) ami06N w=9e-07 l=6e-07 as=1.71e-12 ad=1.71e-12 \
        ps=4.5e-06 pd=4.5e-06 m=1 region=sat
    \+122 (100 99 33 33) ami06N w=9e-07 l=6e-07 as=1.71e-12 ad=1.71e-12 \
        ps=4.5e-06 pd=4.5e-06 m=1 region=sat
    \+121 (90 89 33 33) ami06N w=9e-07 l=6e-07 as=1.71e-12 ad=1.71e-12 \
        ps=4.5e-06 pd=4.5e-06 m=1 region=sat
    \+120 (91 35 33 33) ami06N w=9e-07 l=6e-07 as=1.71e-12 ad=1.71e-12 \
        ps=4.5e-06 pd=4.5e-06 m=1 region=sat
    \+119 (92 91 33 33) ami06N w=9e-07 l=6e-07 as=1.71e-12 ad=1.71e-12 \
        ps=4.5e-06 pd=4.5e-06 m=1 region=sat
    \+118 (93 36 33 33) ami06N w=9e-07 l=6e-07 as=1.71e-12 ad=1.71e-12 \
        ps=4.5e-06 pd=4.5e-06 m=1 region=sat
    \+117 (94 93 33 33) ami06N w=9e-07 l=6e-07 as=1.71e-12 ad=1.71e-12 \
        ps=4.5e-06 pd=4.5e-06 m=1 region=sat
    \+116 (95 Control_Out5 33 33) ami06N w=9e-07 l=6e-07 as=1.71e-12 \
        ad=1.71e-12 ps=4.5e-06 pd=4.5e-06 m=1 region=sat
    \+115 (85 Control_Out0 33 33) ami06N w=9e-07 l=6e-07 as=1.71e-12 \
        ad=1.71e-12 ps=4.5e-06 pd=4.5e-06 m=1 region=sat
    \+114 (96 95 33 33) ami06N w=9e-07 l=6e-07 as=1.71e-12 ad=1.71e-12 \
        ps=4.5e-06 pd=4.5e-06 m=1 region=sat
    \+113 (86 85 33 33) ami06N w=9e-07 l=6e-07 as=1.71e-12 ad=1.71e-12 \
        ps=4.5e-06 pd=4.5e-06 m=1 region=sat
    \+112 (97 Control_Out6 33 33) ami06N w=9e-07 l=6e-07 as=1.71e-12 \
        ad=1.71e-12 ps=4.5e-06 pd=4.5e-06 m=1 region=sat
    \+111 (Control_Out0 69 33 33) ami06N w=9e-07 l=6e-07 as=1.71e-12 \
        ad=1.71e-12 ps=4.5e-06 pd=4.5e-06 m=1 region=sat
    \+110 (Control_Out1 70 33 33) ami06N w=9e-07 l=6e-07 as=1.71e-12 \
        ad=1.71e-12 ps=4.5e-06 pd=4.5e-06 m=1 region=sat
    \+109 (34 71 33 33) ami06N w=9e-07 l=6e-07 as=1.71e-12 ad=1.71e-12 \
        ps=4.5e-06 pd=4.5e-06 m=1 region=sat
    \+108 (35 72 33 33) ami06N w=9e-07 l=6e-07 as=1.71e-12 ad=1.71e-12 \
        ps=4.5e-06 pd=4.5e-06 m=1 region=sat
    \+107 (36 73 33 33) ami06N w=9e-07 l=6e-07 as=1.71e-12 ad=1.71e-12 \
        ps=4.5e-06 pd=4.5e-06 m=1 region=sat
    \+106 (Control_Out5 74 33 33) ami06N w=9e-07 l=6e-07 as=1.71e-12 \
        ad=1.71e-12 ps=4.5e-06 pd=4.5e-06 m=1 region=sat
    \+105 (Control_Out6 75 33 33) ami06N w=9e-07 l=6e-07 as=1.71e-12 \
        ad=1.71e-12 ps=4.5e-06 pd=4.5e-06 m=1 region=sat
    \+104 (Control_Out7 76 33 33) ami06N w=9e-07 l=6e-07 as=1.71e-12 \
        ad=1.71e-12 ps=4.5e-06 pd=4.5e-06 m=1 region=sat
    \+103 (33 Control_Out7 84 33) ami06N w=9e-07 l=6e-07 as=1.71e-12 \
        ad=1.71e-12 ps=4.5e-06 pd=4.5e-06 m=1 region=sat
    \+102 (33 Control_Out0 77 33) ami06N w=9e-07 l=6e-07 as=1.71e-12 \
        ad=1.71e-12 ps=4.5e-06 pd=4.5e-06 m=1 region=sat
    \+101 (33 Control_Out1 78 33) ami06N w=9e-07 l=6e-07 as=1.71e-12 \
        ad=1.71e-12 ps=4.5e-06 pd=4.5e-06 m=1 region=sat
    \+100 (33 34 79 33) ami06N w=9e-07 l=6e-07 as=1.71e-12 ad=1.71e-12 \
        ps=4.5e-06 pd=4.5e-06 m=1 region=sat
    \+99 (33 35 80 33) ami06N w=9e-07 l=6e-07 as=1.71e-12 ad=1.71e-12 \
        ps=4.5e-06 pd=4.5e-06 m=1 region=sat
    \+98 (33 36 81 33) ami06N w=9e-07 l=6e-07 as=1.71e-12 ad=1.71e-12 \
        ps=4.5e-06 pd=4.5e-06 m=1 region=sat
    \+97 (33 Control_Out5 82 33) ami06N w=9e-07 l=6e-07 as=1.71e-12 \
        ad=1.71e-12 ps=4.5e-06 pd=4.5e-06 m=1 region=sat
    \+96 (33 Control_Out6 83 33) ami06N w=9e-07 l=6e-07 as=1.71e-12 \
        ad=1.71e-12 ps=4.5e-06 pd=4.5e-06 m=1 region=sat
    \+95 (81 F1 73 33) ami06N w=9e-07 l=6e-07 as=1.71e-12 ad=1.71e-12 \
        ps=4.5e-06 pd=4.5e-06 m=1 region=sat
    \+94 (82 F1 74 33) ami06N w=9e-07 l=6e-07 as=1.71e-12 ad=1.71e-12 \
        ps=4.5e-06 pd=4.5e-06 m=1 region=sat
    \+93 (83 F1 75 33) ami06N w=9e-07 l=6e-07 as=1.71e-12 ad=1.71e-12 \
        ps=4.5e-06 pd=4.5e-06 m=1 region=sat
    \+92 (84 F1 76 33) ami06N w=9e-07 l=6e-07 as=1.71e-12 ad=1.71e-12 \
        ps=4.5e-06 pd=4.5e-06 m=1 region=sat
    \+91 (77 F1 69 33) ami06N w=9e-07 l=6e-07 as=1.71e-12 ad=1.71e-12 \
        ps=4.5e-06 pd=4.5e-06 m=1 region=sat
    \+90 (78 F1 70 33) ami06N w=9e-07 l=6e-07 as=1.71e-12 ad=1.71e-12 \
        ps=4.5e-06 pd=4.5e-06 m=1 region=sat
    \+89 (79 F1 71 33) ami06N w=9e-07 l=6e-07 as=1.71e-12 ad=1.71e-12 \
        ps=4.5e-06 pd=4.5e-06 m=1 region=sat
    \+88 (80 F1 72 33) ami06N w=9e-07 l=6e-07 as=1.71e-12 ad=1.71e-12 \
        ps=4.5e-06 pd=4.5e-06 m=1 region=sat
    \+87 (70 F2 62 33) ami06N w=9e-07 l=6e-07 as=1.71e-12 ad=1.71e-12 \
        ps=4.5e-06 pd=4.5e-06 m=1 region=sat
    \+86 (71 F2 63 33) ami06N w=9e-07 l=6e-07 as=1.71e-12 ad=1.71e-12 \
        ps=4.5e-06 pd=4.5e-06 m=1 region=sat
    \+85 (72 F2 64 33) ami06N w=9e-07 l=6e-07 as=1.71e-12 ad=1.71e-12 \
        ps=4.5e-06 pd=4.5e-06 m=1 region=sat
    \+84 (73 F2 65 33) ami06N w=9e-07 l=6e-07 as=1.71e-12 ad=1.71e-12 \
        ps=4.5e-06 pd=4.5e-06 m=1 region=sat
    \+83 (74 F2 66 33) ami06N w=9e-07 l=6e-07 as=1.71e-12 ad=1.71e-12 \
        ps=4.5e-06 pd=4.5e-06 m=1 region=sat
    \+82 (75 F2 67 33) ami06N w=9e-07 l=6e-07 as=1.71e-12 ad=1.71e-12 \
        ps=4.5e-06 pd=4.5e-06 m=1 region=sat
    \+81 (76 F2 68 33) ami06N w=9e-07 l=6e-07 as=1.71e-12 ad=1.71e-12 \
        ps=4.5e-06 pd=4.5e-06 m=1 region=sat
    \+80 (69 F2 61 33) ami06N w=9e-07 l=6e-07 as=1.71e-12 ad=1.71e-12 \
        ps=4.5e-06 pd=4.5e-06 m=1 region=sat
    \+79 (61 46 33 33) ami06N w=9e-07 l=6e-07 as=1.71e-12 ad=1.71e-12 \
        ps=4.5e-06 pd=4.5e-06 m=1 region=sat
    \+78 (62 48 33 33) ami06N w=9e-07 l=6e-07 as=1.71e-12 ad=1.71e-12 \
        ps=4.5e-06 pd=4.5e-06 m=1 region=sat
    \+77 (63 50 33 33) ami06N w=9e-07 l=6e-07 as=1.71e-12 ad=1.71e-12 \
        ps=4.5e-06 pd=4.5e-06 m=1 region=sat
    \+76 (64 52 33 33) ami06N w=9e-07 l=6e-07 as=1.71e-12 ad=1.71e-12 \
        ps=4.5e-06 pd=4.5e-06 m=1 region=sat
    \+75 (65 54 33 33) ami06N w=9e-07 l=6e-07 as=1.71e-12 ad=1.71e-12 \
        ps=4.5e-06 pd=4.5e-06 m=1 region=sat
    \+74 (66 56 33 33) ami06N w=9e-07 l=6e-07 as=1.71e-12 ad=1.71e-12 \
        ps=4.5e-06 pd=4.5e-06 m=1 region=sat
    \+73 (67 58 33 33) ami06N w=9e-07 l=6e-07 as=1.71e-12 ad=1.71e-12 \
        ps=4.5e-06 pd=4.5e-06 m=1 region=sat
    \+72 (68 60 33 33) ami06N w=9e-07 l=6e-07 as=1.71e-12 ad=1.71e-12 \
        ps=4.5e-06 pd=4.5e-06 m=1 region=sat
    \+71 (33 67 57 33) ami06N w=9e-07 l=6e-07 as=1.71e-12 ad=1.71e-12 \
        ps=4.5e-06 pd=4.5e-06 m=1 region=sat
    \+70 (33 68 59 33) ami06N w=9e-07 l=6e-07 as=1.71e-12 ad=1.71e-12 \
        ps=4.5e-06 pd=4.5e-06 m=1 region=sat
    \+69 (33 61 45 33) ami06N w=9e-07 l=6e-07 as=1.71e-12 ad=1.71e-12 \
        ps=4.5e-06 pd=4.5e-06 m=1 region=sat
    \+68 (33 62 47 33) ami06N w=9e-07 l=6e-07 as=1.71e-12 ad=1.71e-12 \
        ps=4.5e-06 pd=4.5e-06 m=1 region=sat
    \+67 (33 63 49 33) ami06N w=9e-07 l=6e-07 as=1.71e-12 ad=1.71e-12 \
        ps=4.5e-06 pd=4.5e-06 m=1 region=sat
    \+66 (33 64 51 33) ami06N w=9e-07 l=6e-07 as=1.71e-12 ad=1.71e-12 \
        ps=4.5e-06 pd=4.5e-06 m=1 region=sat
    \+65 (33 65 53 33) ami06N w=9e-07 l=6e-07 as=1.71e-12 ad=1.71e-12 \
        ps=4.5e-06 pd=4.5e-06 m=1 region=sat
    \+64 (33 66 55 33) ami06N w=9e-07 l=6e-07 as=1.71e-12 ad=1.71e-12 \
        ps=4.5e-06 pd=4.5e-06 m=1 region=sat
    \+47 (37 S0 111 33) ami06N w=9e-07 l=6e-07 as=9.9e-13 ad=1.71e-12 \
        ps=2.1e-06 pd=4.5e-06 m=1 region=sat
    \+46 (41 S0B 122 33) ami06N w=9e-07 l=6e-07 as=9.9e-13 ad=1.71e-12 \
        ps=2.1e-06 pd=4.5e-06 m=1 region=sat
    \+45 (38 S0 112 33) ami06N w=9e-07 l=6e-07 as=9.9e-13 ad=1.71e-12 \
        ps=2.1e-06 pd=4.5e-06 m=1 region=sat
    \+44 (41 S0 123 33) ami06N w=9e-07 l=6e-07 as=9.9e-13 ad=1.71e-12 \
        ps=2.1e-06 pd=4.5e-06 m=1 region=sat
    \+43 (38 S0B 113 33) ami06N w=9e-07 l=6e-07 as=9.9e-13 ad=1.71e-12 \
        ps=2.1e-06 pd=4.5e-06 m=1 region=sat
    \+42 (42 S0 124 33) ami06N w=9e-07 l=6e-07 as=9.9e-13 ad=1.71e-12 \
        ps=2.1e-06 pd=4.5e-06 m=1 region=sat
    \+41 (38 S0 114 33) ami06N w=9e-07 l=6e-07 as=9.9e-13 ad=1.71e-12 \
        ps=2.1e-06 pd=4.5e-06 m=1 region=sat
    \+40 (42 S0B 125 33) ami06N w=9e-07 l=6e-07 as=9.9e-13 ad=1.71e-12 \
        ps=2.1e-06 pd=4.5e-06 m=1 region=sat
    \+39 (39 S0 115 33) ami06N w=9e-07 l=6e-07 as=9.9e-13 ad=1.71e-12 \
        ps=2.1e-06 pd=4.5e-06 m=1 region=sat
    \+38 (42 S0 126 33) ami06N w=9e-07 l=6e-07 as=9.9e-13 ad=1.71e-12 \
        ps=2.1e-06 pd=4.5e-06 m=1 region=sat
    \+37 (39 S0B 116 33) ami06N w=9e-07 l=6e-07 as=9.9e-13 ad=1.71e-12 \
        ps=2.1e-06 pd=4.5e-06 m=1 region=sat
    \+36 (43 S0 127 33) ami06N w=9e-07 l=6e-07 as=9.9e-13 ad=1.71e-12 \
        ps=2.1e-06 pd=4.5e-06 m=1 region=sat
    \+35 (39 S0 117 33) ami06N w=9e-07 l=6e-07 as=9.9e-13 ad=1.71e-12 \
        ps=2.1e-06 pd=4.5e-06 m=1 region=sat
    \+34 (43 S0B 128 33) ami06N w=9e-07 l=6e-07 as=9.9e-13 ad=1.71e-12 \
        ps=2.1e-06 pd=4.5e-06 m=1 region=sat
    \+33 (40 S0 118 33) ami06N w=9e-07 l=6e-07 as=9.9e-13 ad=1.71e-12 \
        ps=2.1e-06 pd=4.5e-06 m=1 region=sat
    \+32 (43 S0 129 33) ami06N w=9e-07 l=6e-07 as=9.9e-13 ad=1.71e-12 \
        ps=2.1e-06 pd=4.5e-06 m=1 region=sat
    \+31 (40 S0B 119 33) ami06N w=9e-07 l=6e-07 as=9.9e-13 ad=1.71e-12 \
        ps=2.1e-06 pd=4.5e-06 m=1 region=sat
    \+30 (44 S0 130 33) ami06N w=9e-07 l=6e-07 as=9.9e-13 ad=1.71e-12 \
        ps=2.1e-06 pd=4.5e-06 m=1 region=sat
    \+29 (37 S0 109 33) ami06N w=9e-07 l=6e-07 as=9.9e-13 ad=1.71e-12 \
        ps=2.1e-06 pd=4.5e-06 m=1 region=sat
    \+28 (40 S0 120 33) ami06N w=9e-07 l=6e-07 as=9.9e-13 ad=1.71e-12 \
        ps=2.1e-06 pd=4.5e-06 m=1 region=sat
    \+27 (44 S0B 131 33) ami06N w=9e-07 l=6e-07 as=9.9e-13 ad=1.71e-12 \
        ps=2.1e-06 pd=4.5e-06 m=1 region=sat
    \+26 (37 S0B 110 33) ami06N w=9e-07 l=6e-07 as=9.9e-13 ad=1.71e-12 \
        ps=2.1e-06 pd=4.5e-06 m=1 region=sat
    \+25 (41 S0 121 33) ami06N w=9e-07 l=6e-07 as=9.9e-13 ad=1.71e-12 \
        ps=2.1e-06 pd=4.5e-06 m=1 region=sat
    \+24 (44 S0 132 33) ami06N w=9e-07 l=6e-07 as=9.9e-13 ad=1.71e-12 \
        ps=2.1e-06 pd=4.5e-06 m=1 region=sat
    \+23 (113 S1 In\<1\> 33) ami06N w=9e-07 l=6e-07 as=1.71e-12 ad=9.9e-13 \
        ps=4.5e-06 pd=2.1e-06 m=1 region=sat
    \+22 (124 S1 Control_Out5 33) ami06N w=9e-07 l=6e-07 as=1.71e-12 \
        ad=9.9e-13 ps=4.5e-06 pd=2.1e-06 m=1 region=sat
    \+21 (114 S1B 33 33) ami06N w=9e-07 l=6e-07 as=1.71e-12 ad=9.9e-13 \
        ps=4.5e-06 pd=2.1e-06 m=1 region=sat
    \+20 (125 S1 In\<5\> 33) ami06N w=9e-07 l=6e-07 as=1.71e-12 ad=9.9e-13 \
        ps=4.5e-06 pd=2.1e-06 m=1 region=sat
    \+19 (115 S1 34 33) ami06N w=9e-07 l=6e-07 as=1.71e-12 ad=9.9e-13 \
        ps=4.5e-06 pd=2.1e-06 m=1 region=sat
    \+18 (126 S1B 33 33) ami06N w=9e-07 l=6e-07 as=1.71e-12 ad=9.9e-13 \
        ps=4.5e-06 pd=2.1e-06 m=1 region=sat
    \+17 (116 S1 In\<2\> 33) ami06N w=9e-07 l=6e-07 as=1.71e-12 ad=9.9e-13 \
        ps=4.5e-06 pd=2.1e-06 m=1 region=sat
    \+16 (127 S1 Control_Out6 33) ami06N w=9e-07 l=6e-07 as=1.71e-12 \
        ad=9.9e-13 ps=4.5e-06 pd=2.1e-06 m=1 region=sat
    \+15 (117 S1B 33 33) ami06N w=9e-07 l=6e-07 as=1.71e-12 ad=9.9e-13 \
        ps=4.5e-06 pd=2.1e-06 m=1 region=sat
    \+14 (128 S1 In\<6\> 33) ami06N w=9e-07 l=6e-07 as=1.71e-12 ad=9.9e-13 \
        ps=4.5e-06 pd=2.1e-06 m=1 region=sat
    \+13 (118 S1 35 33) ami06N w=9e-07 l=6e-07 as=1.71e-12 ad=9.9e-13 \
        ps=4.5e-06 pd=2.1e-06 m=1 region=sat
    \+12 (129 S1B 33 33) ami06N w=9e-07 l=6e-07 as=1.71e-12 ad=9.9e-13 \
        ps=4.5e-06 pd=2.1e-06 m=1 region=sat
    \+11 (119 S1 In\<3\> 33) ami06N w=9e-07 l=6e-07 as=1.71e-12 ad=9.9e-13 \
        ps=4.5e-06 pd=2.1e-06 m=1 region=sat
    \+10 (130 S1 Control_Out7 33) ami06N w=9e-07 l=6e-07 as=1.71e-12 \
        ad=9.9e-13 ps=4.5e-06 pd=2.1e-06 m=1 region=sat
    \+9 (109 S1 Control_Out0 33) ami06N w=9e-07 l=6e-07 as=1.71e-12 \
        ad=9.9e-13 ps=4.5e-06 pd=2.1e-06 m=1 region=sat
    \+8 (120 S1B 33 33) ami06N w=9e-07 l=6e-07 as=1.71e-12 ad=9.9e-13 \
        ps=4.5e-06 pd=2.1e-06 m=1 region=sat
    \+7 (131 S1 In\<7\> 33) ami06N w=9e-07 l=6e-07 as=1.71e-12 ad=9.9e-13 \
        ps=4.5e-06 pd=2.1e-06 m=1 region=sat
    \+6 (110 S1 In\<0\> 33) ami06N w=9e-07 l=6e-07 as=1.71e-12 ad=9.9e-13 \
        ps=4.5e-06 pd=2.1e-06 m=1 region=sat
    \+5 (121 S1 36 33) ami06N w=9e-07 l=6e-07 as=1.71e-12 ad=9.9e-13 \
        ps=4.5e-06 pd=2.1e-06 m=1 region=sat
    \+4 (132 S1B 33 33) ami06N w=9e-07 l=6e-07 as=1.71e-12 ad=9.9e-13 \
        ps=4.5e-06 pd=2.1e-06 m=1 region=sat
    \+3 (111 S1B 33 33) ami06N w=9e-07 l=6e-07 as=1.71e-12 ad=9.9e-13 \
        ps=4.5e-06 pd=2.1e-06 m=1 region=sat
    \+2 (122 S1 In\<4\> 33) ami06N w=9e-07 l=6e-07 as=1.71e-12 ad=9.9e-13 \
        ps=4.5e-06 pd=2.1e-06 m=1 region=sat
    \+1 (112 S1 Control_Out1 33) ami06N w=9e-07 l=6e-07 as=1.71e-12 \
        ad=9.9e-13 ps=4.5e-06 pd=2.1e-06 m=1 region=sat
    \+0 (123 S1B 33 33) ami06N w=9e-07 l=6e-07 as=1.71e-12 ad=9.9e-13 \
        ps=4.5e-06 pd=2.1e-06 m=1 region=sat
    \+63 (46 F2 45 33) ami06N w=9e-07 l=6e-07 as=1.71e-12 ad=1.71e-12 \
        ps=4.5e-06 pd=4.5e-06 m=1 region=sat
    \+62 (42 F1 56 33) ami06N w=9e-07 l=6e-07 as=1.71e-12 ad=1.71e-12 \
        ps=4.5e-06 pd=4.5e-06 m=1 region=sat
    \+61 (37 F1 46 33) ami06N w=9e-07 l=6e-07 as=1.71e-12 ad=1.71e-12 \
        ps=4.5e-06 pd=4.5e-06 m=1 region=sat
    \+60 (58 F2 57 33) ami06N w=9e-07 l=6e-07 as=1.71e-12 ad=1.71e-12 \
        ps=4.5e-06 pd=4.5e-06 m=1 region=sat
    \+59 (48 F2 47 33) ami06N w=9e-07 l=6e-07 as=1.71e-12 ad=1.71e-12 \
        ps=4.5e-06 pd=4.5e-06 m=1 region=sat
    \+58 (43 F1 58 33) ami06N w=9e-07 l=6e-07 as=1.71e-12 ad=1.71e-12 \
        ps=4.5e-06 pd=4.5e-06 m=1 region=sat
    \+57 (38 F1 48 33) ami06N w=9e-07 l=6e-07 as=1.71e-12 ad=1.71e-12 \
        ps=4.5e-06 pd=4.5e-06 m=1 region=sat
    \+56 (60 F2 59 33) ami06N w=9e-07 l=6e-07 as=1.71e-12 ad=1.71e-12 \
        ps=4.5e-06 pd=4.5e-06 m=1 region=sat
    \+55 (50 F2 49 33) ami06N w=9e-07 l=6e-07 as=1.71e-12 ad=1.71e-12 \
        ps=4.5e-06 pd=4.5e-06 m=1 region=sat
    \+54 (44 F1 60 33) ami06N w=9e-07 l=6e-07 as=1.71e-12 ad=1.71e-12 \
        ps=4.5e-06 pd=4.5e-06 m=1 region=sat
    \+53 (39 F1 50 33) ami06N w=9e-07 l=6e-07 as=1.71e-12 ad=1.71e-12 \
        ps=4.5e-06 pd=4.5e-06 m=1 region=sat
    \+52 (52 F2 51 33) ami06N w=9e-07 l=6e-07 as=1.71e-12 ad=1.71e-12 \
        ps=4.5e-06 pd=4.5e-06 m=1 region=sat
    \+51 (40 F1 52 33) ami06N w=9e-07 l=6e-07 as=1.71e-12 ad=1.71e-12 \
        ps=4.5e-06 pd=4.5e-06 m=1 region=sat
    \+50 (54 F2 53 33) ami06N w=9e-07 l=6e-07 as=1.71e-12 ad=1.71e-12 \
        ps=4.5e-06 pd=4.5e-06 m=1 region=sat
    \+49 (41 F1 54 33) ami06N w=9e-07 l=6e-07 as=1.71e-12 ad=1.71e-12 \
        ps=4.5e-06 pd=4.5e-06 m=1 region=sat
    \+48 (56 F2 55 33) ami06N w=9e-07 l=6e-07 as=1.71e-12 ad=1.71e-12 \
        ps=4.5e-06 pd=4.5e-06 m=1 region=sat
    \+191 (88 87 32 32) ami06P w=9e-07 l=6e-07 as=1.71e-12 ad=1.71e-12 \
        ps=4.5e-06 pd=4.5e-06 m=1 region=sat
    \+190 (99 Control_Out7 32 32) ami06P w=9e-07 l=6e-07 as=1.71e-12 \
        ad=1.71e-12 ps=4.5e-06 pd=4.5e-06 m=1 region=sat
    \+189 (89 34 32 32) ami06P w=9e-07 l=6e-07 as=1.71e-12 ad=1.71e-12 \
        ps=4.5e-06 pd=4.5e-06 m=1 region=sat
    \+188 (100 99 32 32) ami06P w=9e-07 l=6e-07 as=1.71e-12 ad=1.71e-12 \
        ps=4.5e-06 pd=4.5e-06 m=1 region=sat
    \+187 (90 89 32 32) ami06P w=9e-07 l=6e-07 as=1.71e-12 ad=1.71e-12 \
        ps=4.5e-06 pd=4.5e-06 m=1 region=sat
    \+186 (91 35 32 32) ami06P w=9e-07 l=6e-07 as=1.71e-12 ad=1.71e-12 \
        ps=4.5e-06 pd=4.5e-06 m=1 region=sat
    \+185 (92 91 32 32) ami06P w=9e-07 l=6e-07 as=1.71e-12 ad=1.71e-12 \
        ps=4.5e-06 pd=4.5e-06 m=1 region=sat
    \+184 (93 36 32 32) ami06P w=9e-07 l=6e-07 as=1.71e-12 ad=1.71e-12 \
        ps=4.5e-06 pd=4.5e-06 m=1 region=sat
    \+183 (94 93 32 32) ami06P w=9e-07 l=6e-07 as=1.71e-12 ad=1.71e-12 \
        ps=4.5e-06 pd=4.5e-06 m=1 region=sat
    \+182 (95 Control_Out5 32 32) ami06P w=9e-07 l=6e-07 as=1.71e-12 \
        ad=1.71e-12 ps=4.5e-06 pd=4.5e-06 m=1 region=sat
    \+181 (85 Control_Out0 32 32) ami06P w=9e-07 l=6e-07 as=1.71e-12 \
        ad=1.71e-12 ps=4.5e-06 pd=4.5e-06 m=1 region=sat
    \+180 (96 95 32 32) ami06P w=9e-07 l=6e-07 as=1.71e-12 ad=1.71e-12 \
        ps=4.5e-06 pd=4.5e-06 m=1 region=sat
    \+179 (86 85 32 32) ami06P w=9e-07 l=6e-07 as=1.71e-12 ad=1.71e-12 \
        ps=4.5e-06 pd=4.5e-06 m=1 region=sat
    \+178 (97 Control_Out6 32 32) ami06P w=9e-07 l=6e-07 as=1.71e-12 \
        ad=1.71e-12 ps=4.5e-06 pd=4.5e-06 m=1 region=sat
    \+177 (87 Control_Out1 32 32) ami06P w=9e-07 l=6e-07 as=1.71e-12 \
        ad=1.71e-12 ps=4.5e-06 pd=4.5e-06 m=1 region=sat
    \+176 (98 97 32 32) ami06P w=9e-07 l=6e-07 as=1.71e-12 ad=1.71e-12 \
        ps=4.5e-06 pd=4.5e-06 m=1 region=sat
    \+175 (Control_Out0 69 32 32) ami06P w=9e-07 l=6e-07 as=1.71e-12 \
        ad=1.71e-12 ps=4.5e-06 pd=4.5e-06 m=1 region=sat
    \+174 (Control_Out1 70 32 32) ami06P w=9e-07 l=6e-07 as=1.71e-12 \
        ad=1.71e-12 ps=4.5e-06 pd=4.5e-06 m=1 region=sat
    \+173 (34 71 32 32) ami06P w=9e-07 l=6e-07 as=1.71e-12 ad=1.71e-12 \
        ps=4.5e-06 pd=4.5e-06 m=1 region=sat
    \+172 (35 72 32 32) ami06P w=9e-07 l=6e-07 as=1.71e-12 ad=1.71e-12 \
        ps=4.5e-06 pd=4.5e-06 m=1 region=sat
    \+171 (36 73 32 32) ami06P w=9e-07 l=6e-07 as=1.71e-12 ad=1.71e-12 \
        ps=4.5e-06 pd=4.5e-06 m=1 region=sat
    \+170 (Control_Out5 74 32 32) ami06P w=9e-07 l=6e-07 as=1.71e-12 \
        ad=1.71e-12 ps=4.5e-06 pd=4.5e-06 m=1 region=sat
    \+169 (Control_Out6 75 32 32) ami06P w=9e-07 l=6e-07 as=1.71e-12 \
        ad=1.71e-12 ps=4.5e-06 pd=4.5e-06 m=1 region=sat
    \+168 (Control_Out7 76 32 32) ami06P w=9e-07 l=6e-07 as=1.71e-12 \
        ad=1.71e-12 ps=4.5e-06 pd=4.5e-06 m=1 region=sat
    \+167 (32 Control_Out0 77 32) ami06P w=9e-07 l=6e-07 as=1.71e-12 \
        ad=1.71e-12 ps=4.5e-06 pd=4.5e-06 m=1 region=sat
    \+166 (32 Control_Out1 78 32) ami06P w=9e-07 l=6e-07 as=1.71e-12 \
        ad=1.71e-12 ps=4.5e-06 pd=4.5e-06 m=1 region=sat
    \+165 (32 34 79 32) ami06P w=9e-07 l=6e-07 as=1.71e-12 ad=1.71e-12 \
        ps=4.5e-06 pd=4.5e-06 m=1 region=sat
    \+164 (32 35 80 32) ami06P w=9e-07 l=6e-07 as=1.71e-12 ad=1.71e-12 \
        ps=4.5e-06 pd=4.5e-06 m=1 region=sat
    \+163 (32 36 81 32) ami06P w=9e-07 l=6e-07 as=1.71e-12 ad=1.71e-12 \
        ps=4.5e-06 pd=4.5e-06 m=1 region=sat
    \+162 (32 Control_Out5 82 32) ami06P w=9e-07 l=6e-07 as=1.71e-12 \
        ad=1.71e-12 ps=4.5e-06 pd=4.5e-06 m=1 region=sat
    \+161 (32 Control_Out6 83 32) ami06P w=9e-07 l=6e-07 as=1.71e-12 \
        ad=1.71e-12 ps=4.5e-06 pd=4.5e-06 m=1 region=sat
    \+160 (32 Control_Out7 84 32) ami06P w=9e-07 l=6e-07 as=1.71e-12 \
        ad=1.71e-12 ps=4.5e-06 pd=4.5e-06 m=1 region=sat
    \+159 (66 56 32 32) ami06P w=9e-07 l=6e-07 as=1.71e-12 ad=1.71e-12 \
        ps=4.5e-06 pd=4.5e-06 m=1 region=sat
    \+158 (67 58 32 32) ami06P w=9e-07 l=6e-07 as=1.71e-12 ad=1.71e-12 \
        ps=4.5e-06 pd=4.5e-06 m=1 region=sat
    \+157 (68 60 32 32) ami06P w=9e-07 l=6e-07 as=1.71e-12 ad=1.71e-12 \
        ps=4.5e-06 pd=4.5e-06 m=1 region=sat
    \+156 (61 46 32 32) ami06P w=9e-07 l=6e-07 as=1.71e-12 ad=1.71e-12 \
        ps=4.5e-06 pd=4.5e-06 m=1 region=sat
    \+155 (62 48 32 32) ami06P w=9e-07 l=6e-07 as=1.71e-12 ad=1.71e-12 \
        ps=4.5e-06 pd=4.5e-06 m=1 region=sat
    \+154 (63 50 32 32) ami06P w=9e-07 l=6e-07 as=1.71e-12 ad=1.71e-12 \
        ps=4.5e-06 pd=4.5e-06 m=1 region=sat
    \+153 (64 52 32 32) ami06P w=9e-07 l=6e-07 as=1.71e-12 ad=1.71e-12 \
        ps=4.5e-06 pd=4.5e-06 m=1 region=sat
    \+152 (65 54 32 32) ami06P w=9e-07 l=6e-07 as=1.71e-12 ad=1.71e-12 \
        ps=4.5e-06 pd=4.5e-06 m=1 region=sat
    \+151 (32 63 49 32) ami06P w=9e-07 l=6e-07 as=1.71e-12 ad=1.71e-12 \
        ps=4.5e-06 pd=4.5e-06 m=1 region=sat
    \+150 (32 64 51 32) ami06P w=9e-07 l=6e-07 as=1.71e-12 ad=1.71e-12 \
        ps=4.5e-06 pd=4.5e-06 m=1 region=sat
    \+149 (32 65 53 32) ami06P w=9e-07 l=6e-07 as=1.71e-12 ad=1.71e-12 \
        ps=4.5e-06 pd=4.5e-06 m=1 region=sat
    \+148 (32 66 55 32) ami06P w=9e-07 l=6e-07 as=1.71e-12 ad=1.71e-12 \
        ps=4.5e-06 pd=4.5e-06 m=1 region=sat
    \+147 (32 67 57 32) ami06P w=9e-07 l=6e-07 as=1.71e-12 ad=1.71e-12 \
        ps=4.5e-06 pd=4.5e-06 m=1 region=sat
    \+146 (32 68 59 32) ami06P w=9e-07 l=6e-07 as=1.71e-12 ad=1.71e-12 \
        ps=4.5e-06 pd=4.5e-06 m=1 region=sat
    \+145 (32 61 45 32) ami06P w=9e-07 l=6e-07 as=1.71e-12 ad=1.71e-12 \
        ps=4.5e-06 pd=4.5e-06 m=1 region=sat
    \+144 (32 62 47 32) ami06P w=9e-07 l=6e-07 as=1.71e-12 ad=1.71e-12 \
        ps=4.5e-06 pd=4.5e-06 m=1 region=sat
ends IR_reg
// End of subcircuit definition.

// Library name: cse463_project
// Cell name: drive_bus_test
// View name: schematic
I0 (net6 net7 net8 net9 net10 net11 net12 net13 F1 F2 net14 net15 net16 \
        net17 net18 net19 net20 net21 net22 net23 net24 net25 net037\<0\> \
        net037\<1\> net037\<2\> net037\<3\> net037\<4\> net037\<5\> \
        net037\<6\> net037\<7\> net26 net27 net28 net29 net30 net31 net32 \
        net33 net34 net35 net36 net37) bus_top
I1 (net46 net47 net48 net49 net50 F1 F2 IN\<0\> IN\<1\> IN\<2\> IN\<3\> \
        IN\<4\> IN\<5\> IN\<6\> IN\<7\> IR_N0 IR_N0B IR_N1 IR_N1B \
        net037\<0\> net037\<1\> net037\<2\> net037\<3\> net037\<4\> \
        net037\<5\> net037\<6\> net037\<7\> IR_S0 IR_S0B IR_S1 IR_S1B) \
        IR_reg
V18 (IN\<6\> 0) vsource type=pulse val0=0 val1=0 period=600n width=300n
V17 (IN\<7\> 0) vsource type=pulse val0=0 val1=0 period=600n width=300n
V11 (IN\<4\> 0) vsource type=pulse val0=0 val1=0 period=600n width=300n
V12 (IN\<5\> 0) vsource type=pulse val0=0 val1=0 period=600n width=300n
V13 (IN\<2\> 0) vsource type=pulse val0=0 val1=0 period=600n width=300n
V14 (IN\<3\> 0) vsource type=pulse val0=0 val1=0 period=600n width=300n
V15 (IN\<0\> 0) vsource type=pulse val0=5 val1=0 period=800n delay=25n \
        width=400n
V16 (IN\<1\> 0) vsource type=pulse val0=0 val1=0 period=600n width=300n
V31 (F2 0) vsource type=pulse val0=0 val1=5 period=200n delay=124n \
        width=50n
V30 (F1 0) vsource type=pulse val0=0 val1=5 period=200n width=100n
V19 (vdd! 0) vsource type=dc dc=5
V10 (IR_S1B 0) vsource type=dc dc=0
V9 (IR_S0 0) vsource type=dc dc=0
V8 (IR_S0B 0) vsource type=dc dc=5
V7 (IR_S1 0) vsource type=dc dc=5
V6 (IR_N1 0) vsource type=dc dc=0
V5 (IR_N1B 0) vsource type=dc dc=5
V4 (IR_N0 0) vsource type=dc dc=0
V2 (IR_N0B 0) vsource type=dc dc=5
simulatorOptions options reltol=1e-3 vabstol=1e-6 iabstol=1e-12 temp=27 \
    tnom=27 scalem=1.0 scale=1.0 gmin=1e-12 rforce=1 maxnotes=5 maxwarns=5 \
    digits=5 cols=80 pivrel=1e-3 sensfile="../psf/sens.output" \
    checklimitdest=psf
tran tran stop=3.6u write="spectre.ic" writefinal="spectre.fc" \
    annotate=status maxiters=5
finalTimeOP info what=oppoint where=rawfile
modelParameter info what=models where=rawfile
element info what=inst where=rawfile
outputParameter info what=output where=rawfile
designParamVals info what=parameters where=rawfile
primitives info what=primitives where=rawfile
subckts info what=subckts where=rawfile
saveOptions options save=allpub
