simulator( 'spectre )
design(	 "/home/warehouse/lbremer/cadence/simulation/drive_bus_test/spectre/schematic/netlist/netlist")
resultsDir( "/home/warehouse/lbremer/cadence/simulation/drive_bus_test/spectre/schematic" )
modelFile(
    '("/project/linuxlab/cadence/CDK/ncsu/models/spectre/nom/ami06N.m" "")
    '("/project/linuxlab/cadence/CDK/ncsu/models/spectre/nom/ami06P.m" "")
)
analysis('tran ?stop "1.2u"  )
envOption(
	'analysisOrder  list("tran")
)
temp( 27 )
run()
selectResult( 'tran )
plot(getData("/F2") getData("/F1") getData("/net5<0>") getData("/IN<0>") )
modelFile(
    '("/project/linuxlab/cadence/CDK/ncsu/models/spectre/nom/ami06N.m" "")
    '("/project/linuxlab/cadence/CDK/ncsu/models/spectre/nom/ami06P.m" "")
)
run()
selectResult( 'tran )
plot(getData("/F2") getData("/F1") getData("/net5<0>") getData("/IN<0>") )
modelFile(
    '("/project/linuxlab/cadence/CDK/ncsu/models/spectre/nom/ami06N.m" "")
    '("/project/linuxlab/cadence/CDK/ncsu/models/spectre/nom/ami06P.m" "")
)
run()
selectResult( 'tran )
plot(getData("/F2") getData("/F1") getData("/net5<0>") getData("/IN<0>") )
modelFile(
    '("/project/linuxlab/cadence/CDK/ncsu/models/spectre/nom/ami06N.m" "")
    '("/project/linuxlab/cadence/CDK/ncsu/models/spectre/nom/ami06P.m" "")
)
run()
selectResult( 'tran )
plot(getData("/IN<0>") getData("/net5<0>") getData("/F1") getData("/F2") )
modelFile(
    '("/project/linuxlab/cadence/CDK/ncsu/models/spectre/nom/ami06N.m" "")
    '("/project/linuxlab/cadence/CDK/ncsu/models/spectre/nom/ami06P.m" "")
)
run()
selectResult( 'tran )
plot(getData("/IN<0>") getData("/net5<0>") getData("/F1") getData("/F2") )
modelFile(
    '("/project/linuxlab/cadence/CDK/ncsu/models/spectre/nom/ami06N.m" "")
    '("/project/linuxlab/cadence/CDK/ncsu/models/spectre/nom/ami06P.m" "")
)
run()
selectResult( 'tran )
plot(getData("/IN<0>") getData("/net5<0>") getData("/F1") getData("/F2") getData("/net46") )
modelFile(
    '("/project/linuxlab/cadence/CDK/ncsu/models/spectre/nom/ami06N.m" "")
    '("/project/linuxlab/cadence/CDK/ncsu/models/spectre/nom/ami06P.m" "")
)
analysis('tran ?stop "600n"  )
run()
selectResult( 'tran )
plot(getData("/I1/I60/net13") getData("/IN<0>") getData("/net5<0>") getData("/F1") getData("/F2") getData("/net46") )
modelFile(
    '("/project/linuxlab/cadence/CDK/ncsu/models/spectre/nom/ami06N.m" "")
    '("/project/linuxlab/cadence/CDK/ncsu/models/spectre/nom/ami06P.m" "")
)
run()
selectResult( 'tran )
plot(getData("/IN<0>") getData("/net5<0>") getData("/F1") getData("/F2") getData("/net46") getData("/I1/I60/net13") )
modelFile(
    '("/project/linuxlab/cadence/CDK/ncsu/models/spectre/nom/ami06N.m" "")
    '("/project/linuxlab/cadence/CDK/ncsu/models/spectre/nom/ami06P.m" "")
)
run()
selectResult( 'tran )
plot(getData("/net5<0>") getData("/net5<1>") getData("/net5<2>") getData("/net5<3>") getData("/net5<4>") getData("/net5<5>") getData("/net5<6>") getData("/net5<7>") getData("/IN<0>") getData("/IN<1>") getData("/IN<2>") getData("/IN<3>") getData("/IN<4>") getData("/IN<5>") getData("/IN<6>") getData("/IN<7>") )
modelFile(
    '("/project/linuxlab/cadence/CDK/ncsu/models/spectre/nom/ami06N.m" "")
    '("/project/linuxlab/cadence/CDK/ncsu/models/spectre/nom/ami06P.m" "")
)
run()
selectResult( 'tran )
plot(getData("/net5<0>") getData("/net5<1>") getData("/net5<2>") getData("/net5<3>") getData("/net5<4>") getData("/net5<5>") getData("/net5<6>") getData("/net5<7>") )
modelFile(
    '("/project/linuxlab/cadence/CDK/ncsu/models/spectre/nom/ami06N.m" "")
    '("/project/linuxlab/cadence/CDK/ncsu/models/spectre/nom/ami06P.m" "")
)
save( 'i "/I1/Control_Out0" "/I1/S1" "/I1/S1B" "/I1/S0" "/I1/S0B" "/I1/N1" "/I1/N1B" "/I1/N0" "/I1/N0B" "/I1/F1" "/I1/F2" )
run()
selectResult( 'tran )
plot(getData("/I1/Control_Out0") getData("/I1/S1") getData("/I1/S1B") getData("/I1/S0") getData("/I1/S0B") getData("/I1/N1") getData("/I1/N1B") getData("/I1/N0") getData("/I1/N0B") getData("/I1/F1") getData("/I1/F2") getData("/net46") getData("/I1/net77") getData("/net47") getData("/I1/net81") )
modelFile(
    '("/project/linuxlab/cadence/CDK/ncsu/models/spectre/nom/ami06N.m" "")
    '("/project/linuxlab/cadence/CDK/ncsu/models/spectre/nom/ami06P.m" "")
)
save( 'i /I1/Control_Out0 /I1/S1 /I1/S1B /I1/S0 /I1/S0B /I1/N1 /I1/N1B /I1/N0 /I1/N0B /I1/F1 /I1/F2 )
run()
selectResult( 'tran )
plot(getData("/I1/I60/net13") getData("/I1/I60/I6/net2") getData("/IN<0>") )
modelFile(
    '("/project/linuxlab/cadence/CDK/ncsu/models/spectre/nom/ami06N.m" "")
    '("/project/linuxlab/cadence/CDK/ncsu/models/spectre/nom/ami06P.m" "")
)
run()
selectResult( 'tran )
plot(getData("/I1/I60/net13") getData("/IN<0>") )
modelFile(
    '("/project/linuxlab/cadence/CDK/ncsu/models/spectre/nom/ami06N.m" "")
    '("/project/linuxlab/cadence/CDK/ncsu/models/spectre/nom/ami06P.m" "")
)
run()
selectResult( 'tran )
plot(getData("/net46") getData("/I1/I60/I0/net5") getData("/I1/I60/net13") getData("/IN<0>") )
modelFile(
    '("/project/linuxlab/cadence/CDK/ncsu/models/spectre/nom/ami06N.m" "")
    '("/project/linuxlab/cadence/CDK/ncsu/models/spectre/nom/ami06P.m" "")
)
run()
selectResult( 'tran )
plot(getData("/F2") getData("/F1") getData("/net46") getData("/I1/I60/I0/net5") getData("/I1/I60/net13") getData("/IN<0>") )
modelFile(
    '("/project/linuxlab/cadence/CDK/ncsu/models/spectre/nom/ami06N.m" "")
    '("/project/linuxlab/cadence/CDK/ncsu/models/spectre/nom/ami06P.m" "")
)
run()
selectResult( 'tran )
plot(getData("/IN<0>") getData("/I1/I60/net13") getData("/I1/I60/I0/net5") getData("/net46") getData("/F1") getData("/F2") )
modelFile(
    '("/project/linuxlab/cadence/CDK/ncsu/models/spectre/nom/ami06N.m" "")
    '("/project/linuxlab/cadence/CDK/ncsu/models/spectre/nom/ami06P.m" "")
)
run()
selectResult( 'tran )
plot(getData("/net46") getData("/IN<0>") getData("/F1") getData("/F2") )
modelFile(
    '("/project/linuxlab/cadence/CDK/ncsu/models/spectre/nom/ami06N.m" "")
    '("/project/linuxlab/cadence/CDK/ncsu/models/spectre/nom/ami06P.m" "")
)
run()
selectResult( 'tran )
plot(getData("/Out<0>") getData("/IN<0>") getData("/F1") getData("/F2") )
modelFile(
    '("/project/linuxlab/cadence/CDK/ncsu/models/spectre/nom/ami06N.m" "")
    '("/project/linuxlab/cadence/CDK/ncsu/models/spectre/nom/ami06P.m" "")
)
run()
selectResult( 'tran )
plot(getData("/IN<0>") getData("/F1") getData("/F2") getData("/Out<0>") )
modelFile(
    '("/project/linuxlab/cadence/CDK/ncsu/models/spectre/nom/ami06N.m" "")
    '("/project/linuxlab/cadence/CDK/ncsu/models/spectre/nom/ami06P.m" "")
)
run()
selectResult( 'tran )
plot(getData("/net037<0>") getData("/IN<0>") getData("/F1") getData("/F2") )
modelFile(
    '("/project/linuxlab/cadence/CDK/ncsu/models/spectre/nom/ami06N.m" "")
    '("/project/linuxlab/cadence/CDK/ncsu/models/spectre/nom/ami06P.m" "")
)
analysis('tran ?stop "1.8u"  )
run()
selectResult( 'tran )
plot(getData("/IN<0>") getData("/F1") getData("/F2") getData("/net037<0>") )
modelFile(
    '("/project/linuxlab/cadence/CDK/ncsu/models/spectre/nom/ami06N.m" "")
    '("/project/linuxlab/cadence/CDK/ncsu/models/spectre/nom/ami06P.m" "")
)
run()
selectResult( 'tran )
plot(getData("/IN<0>") getData("/F1") getData("/F2") getData("/net037<0>") )
modelFile(
    '("/project/linuxlab/cadence/CDK/ncsu/models/spectre/nom/ami06N.m" "")
    '("/project/linuxlab/cadence/CDK/ncsu/models/spectre/nom/ami06P.m" "")
)
run()
selectResult( 'tran )
plot(getData("/IN<0>") getData("/F1") getData("/F2") getData("/net037<0>") )
modelFile(
    '("/project/linuxlab/cadence/CDK/ncsu/models/spectre/nom/ami06N.m" "")
    '("/project/linuxlab/cadence/CDK/ncsu/models/spectre/nom/ami06P.m" "")
)
run()
selectResult( 'tran )
plot(getData("/IN<0>") getData("/F1") getData("/F2") getData("/net037<0>") )
modelFile(
    '("/project/linuxlab/cadence/CDK/ncsu/models/spectre/nom/ami06N.m" "")
    '("/project/linuxlab/cadence/CDK/ncsu/models/spectre/nom/ami06P.m" "")
)
run()
selectResult( 'tran )
plot(getData("/net46") getData("/IN<0>") getData("/F1") getData("/F2") getData("/net037<0>") )
modelFile(
    '("/project/linuxlab/cadence/CDK/ncsu/models/spectre/nom/ami06N.m" "")
    '("/project/linuxlab/cadence/CDK/ncsu/models/spectre/nom/ami06P.m" "")
)
run()
selectResult( 'tran )
plot(getData("/IN<0>") getData("/F1") getData("/F2") getData("/net037<0>") getData("/net46") )
modelFile(
    '("/project/linuxlab/cadence/CDK/ncsu/models/spectre/nom/ami06N.m" "")
    '("/project/linuxlab/cadence/CDK/ncsu/models/spectre/nom/ami06P.m" "")
)
analysis('tran ?stop "3.6u"  )
run()
selectResult( 'tran )
plot(getData("/IN<0>") getData("/F1") getData("/F2") getData("/net037<0>") getData("/net46") )
modelFile(
    '("/project/linuxlab/cadence/CDK/ncsu/models/spectre/nom/ami06N.m" "")
    '("/project/linuxlab/cadence/CDK/ncsu/models/spectre/nom/ami06P.m" "")
)
run()
selectResult( 'tran )
plot(getData("/IN<0>") getData("/F1") getData("/F2") getData("/net037<0>") getData("/net46") )
modelFile(
    '("/project/linuxlab/cadence/CDK/ncsu/models/spectre/nom/ami06N.m" "")
    '("/project/linuxlab/cadence/CDK/ncsu/models/spectre/nom/ami06P.m" "")
)
run()
selectResult( 'tran )
plot(getData("/IN<0>") getData("/F1") getData("/F2") getData("/net037<0>") getData("/net46") )
modelFile(
    '("/project/linuxlab/cadence/CDK/ncsu/models/spectre/nom/ami06N.m" "")
    '("/project/linuxlab/cadence/CDK/ncsu/models/spectre/nom/ami06P.m" "")
)
run()
selectResult( 'tran )
plot(getData("/IN<0>") getData("/F1") getData("/F2") getData("/net037<0>") getData("/net46") )
modelFile(
    '("/project/linuxlab/cadence/CDK/ncsu/models/spectre/nom/ami06N.m" "")
    '("/project/linuxlab/cadence/CDK/ncsu/models/spectre/nom/ami06P.m" "")
)
run()
selectResult( 'tran )
plot(getData("/IN<0>") getData("/F1") getData("/F2") getData("/net037<0>") getData("/net46") )
modelFile(
    '("/project/linuxlab/cadence/CDK/ncsu/models/spectre/nom/ami06N.m" "")
    '("/project/linuxlab/cadence/CDK/ncsu/models/spectre/nom/ami06P.m" "")
)
run()
selectResult( 'tran )
plot(getData("/IN<0>") getData("/F1") getData("/F2") getData("/net037<0>") getData("/net46") )
modelFile(
    '("/project/linuxlab/cadence/CDK/ncsu/models/spectre/nom/ami06N.m" "")
    '("/project/linuxlab/cadence/CDK/ncsu/models/spectre/nom/ami06P.m" "")
)
run()
selectResult( 'tran )
plot(getData("/IN<0>") getData("/F1") getData("/F2") getData("/net037<0>") getData("/net46") )
modelFile(
    '("/project/linuxlab/cadence/CDK/ncsu/models/spectre/nom/ami06N.m" "")
    '("/project/linuxlab/cadence/CDK/ncsu/models/spectre/nom/ami06P.m" "")
)
run()
selectResult( 'tran )
plot(getData("/IN<0>") getData("/F1") getData("/F2") getData("/net037<0>") getData("/net46") )
