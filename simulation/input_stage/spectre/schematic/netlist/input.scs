// Design: cse562/input_stage
simulator lang=spectre
global 0 vdd!
parameters pW=900n pL=600n nW=900n nL=600n I_0=100n
include "/project/linuxlab/cadence/CDK/ncsu/models/spectre/nom/ami06N.m"
include "/project/linuxlab/cadence/CDK/ncsu/models/spectre/nom/ami06P.m"

// cse562/input_stage/schematic
N8 (net012 net05 net026 net026) ami06N w=nW l=nL m=1 region=sat
N7 (net016 net05 0 0) ami06N w=nW l=nL m=1 region=sat
N2 (net11 net2 net10 net10) ami06N w=900n l=600n m=1 region=sat
N0 (net2 net2 net1 net1) ami06N w=900n l=600n m=1 region=sat
N3 (net10 net1 0 0) ami06N w=900n l=600n m=1 region=sat
N1 (net1 net1 0 0) ami06N w=900n l=600n m=1 region=sat
I16 (net013 0) isource type=dc dc=I_0 m=1
I0 (vdd! net2) isource type=dc dc=1m m=1
R1 (net026 0) resistor r=1K m=1
R0 (vdd! net11) resistor r=1K m=1
V5 (net05 0) vsource type=dc dc=3
V0 (vdd! 0) vsource type=dc dc=3
P9 (net026 net016 net012 net012) ami06P w=pW l=pL m=1 region=sat
P8 (net016 net05 vdd! vdd!) ami06P w=pW l=pL m=1 region=sat
P7 (net012 net013 net09 net09) ami06P w=pW l=pL m=1 region=sat
P6 (net09 net03 vdd! vdd!) ami06P w=pW l=pL m=1 region=sat
P5 (net013 net013 net03 net03) ami06P w=pW l=pL m=1 region=sat
P4 (net03 net03 vdd! vdd!) ami06P w=pW l=pL m=1 region=sat
simulatorOptions options temp=27
dcOp dc
dc dc dev=V5 param=dc start=0 stop=3
save I16:sink P7:s R1:1
