simulator( 'spectre )
design(	 "/home/warehouse/lbremer/cadence/simulation/bus_test/spectre/schematic/netlist/netlist")
resultsDir( "/home/warehouse/lbremer/cadence/simulation/bus_test/spectre/schematic" )
modelFile(
    '("/project/linuxlab/cadence/CDK/ncsu/models/spectre/nom/ami06N.m" "")
    '("/project/linuxlab/cadence/CDK/ncsu/models/spectre/nom/ami06P.m" "")
)
analysis('tran ?stop "800n"  )
envOption(
	'analysisOrder  list("tran")
)
temp( 27 )
run()
selectResult( 'tran )
plot(getData("/Bus<0>") getData("/Bus<1>") getData("/Bus<2>") getData("/Bus<3>") getData("/Bus<4>") getData("/Bus<5>") getData("/Bus<6>") getData("/Bus<7>") getData("/Input<0>") getData("/Input<1>") getData("/Input<2>") getData("/Input<3>") getData("/Input<4>") getData("/Input<5>") getData("/Input<6>") getData("/Input<7>") )
modelFile(
    '("/project/linuxlab/cadence/CDK/ncsu/models/spectre/nom/ami06N.m" "")
    '("/project/linuxlab/cadence/CDK/ncsu/models/spectre/nom/ami06P.m" "")
)
run()
selectResult( 'tran )
plot(getData("/Input<0>") getData("/Input<1>") getData("/Input<2>") getData("/Input<3>") getData("/Input<4>") getData("/Input<5>") getData("/Input<6>") getData("/Input<7>") getData("/Bus<0>") getData("/Bus<1>") getData("/Bus<2>") getData("/Bus<3>") getData("/Bus<4>") getData("/Bus<5>") getData("/Bus<6>") getData("/Bus<7>") )
modelFile(
    '("/project/linuxlab/cadence/CDK/ncsu/models/spectre/nom/ami06N.m" "")
    '("/project/linuxlab/cadence/CDK/ncsu/models/spectre/nom/ami06P.m" "")
)
run()
selectResult( 'tran )
plot(getData("/I1/net74") getData("/Input<0>") getData("/Input<1>") getData("/Input<2>") getData("/Input<3>") getData("/Input<4>") getData("/Input<5>") getData("/Input<6>") getData("/Input<7>") getData("/Bus<0>") getData("/Bus<1>") getData("/Bus<2>") getData("/Bus<3>") getData("/Bus<4>") getData("/Bus<5>") getData("/Bus<6>") getData("/Bus<7>") )
modelFile(
    '("/project/linuxlab/cadence/CDK/ncsu/models/spectre/nom/ami06N.m" "")
    '("/project/linuxlab/cadence/CDK/ncsu/models/spectre/nom/ami06P.m" "")
)
run()
selectResult( 'tran )
plot(getData("/Bus<0>") getData("/Bus<1>") getData("/Bus<2>") getData("/Bus<3>") getData("/Bus<4>") getData("/Bus<5>") getData("/Bus<6>") getData("/Bus<7>") getData("/Input<0>") getData("/Input<1>") getData("/Input<2>") getData("/Input<3>") getData("/Input<4>") getData("/Input<5>") getData("/Input<6>") getData("/Input<7>") )
modelFile(
    '("/project/linuxlab/cadence/CDK/ncsu/models/spectre/nom/ami06N.m" "")
    '("/project/linuxlab/cadence/CDK/ncsu/models/spectre/nom/ami06P.m" "")
)
run()
selectResult( 'tran )
plot(getData("/Input<0>") getData("/Input<1>") getData("/Input<2>") getData("/Input<3>") getData("/Input<4>") getData("/Input<5>") getData("/Input<6>") getData("/Input<7>") getData("/Bus<0>") getData("/Bus<1>") getData("/Bus<2>") getData("/Bus<3>") getData("/Bus<4>") getData("/Bus<5>") getData("/Bus<6>") getData("/Bus<7>") )
modelFile(
    '("/project/linuxlab/cadence/CDK/ncsu/models/spectre/nom/ami06N.m" "")
    '("/project/linuxlab/cadence/CDK/ncsu/models/spectre/nom/ami06P.m" "")
)
run()
selectResult( 'tran )
plot(getData("/I14/net74") getData("/Input<0>") getData("/Input<1>") getData("/Input<2>") getData("/Input<3>") getData("/Input<4>") getData("/Input<5>") getData("/Input<6>") getData("/Input<7>") getData("/Bus<0>") getData("/Bus<1>") getData("/Bus<2>") getData("/Bus<3>") getData("/Bus<4>") getData("/Bus<5>") getData("/Bus<6>") getData("/Bus<7>") )
modelFile(
    '("/project/linuxlab/cadence/CDK/ncsu/models/spectre/nom/ami06N.m" "")
    '("/project/linuxlab/cadence/CDK/ncsu/models/spectre/nom/ami06P.m" "")
)
run()
selectResult( 'tran )
plot(getData("/I14/I60/net13") getData("/Input<0>") getData("/Input<1>") getData("/Input<2>") getData("/Input<3>") getData("/Input<4>") getData("/Input<5>") getData("/Input<6>") getData("/Input<7>") getData("/Bus<0>") getData("/Bus<1>") getData("/Bus<2>") getData("/Bus<3>") getData("/Bus<4>") getData("/Bus<5>") getData("/Bus<6>") getData("/Bus<7>") )
modelFile(
    '("/project/linuxlab/cadence/CDK/ncsu/models/spectre/nom/ami06N.m" "")
    '("/project/linuxlab/cadence/CDK/ncsu/models/spectre/nom/ami06P.m" "")
)
run()
selectResult( 'tran )
plot(getData("/I14/I60/net13") getData("/I14/I60/I6/net3") getData("/I14/net74") )
modelFile(
    '("/project/linuxlab/cadence/CDK/ncsu/models/spectre/nom/ami06N.m" "")
    '("/project/linuxlab/cadence/CDK/ncsu/models/spectre/nom/ami06P.m" "")
)
run()
selectResult( 'tran )
plot(getData("/I14/I60/net13") getData("/Input<0>") )
modelFile(
    '("/project/linuxlab/cadence/CDK/ncsu/models/spectre/nom/ami06N.m" "")
    '("/project/linuxlab/cadence/CDK/ncsu/models/spectre/nom/ami06P.m" "")
)
run()
selectResult( 'tran )
plot(getData("/net017") getData("/net01") getData("/Input<0>") getData("/I14/I60/net13") )
modelFile(
    '("/project/linuxlab/cadence/CDK/ncsu/models/spectre/nom/ami06N.m" "")
    '("/project/linuxlab/cadence/CDK/ncsu/models/spectre/nom/ami06P.m" "")
)
run()
selectResult( 'tran )
plot(getData("/Input<0>") getData("/I14/I60/net13") getData("/net01") getData("/net017") )
modelFile(
    '("/project/linuxlab/cadence/CDK/ncsu/models/spectre/nom/ami06N.m" "")
    '("/project/linuxlab/cadence/CDK/ncsu/models/spectre/nom/ami06P.m" "")
)
run()
selectResult( 'tran )
plot(getData("/Bus<0>") getData("/Bus<1>") getData("/Bus<2>") getData("/Bus<3>") getData("/Bus<4>") getData("/Bus<5>") getData("/Bus<6>") getData("/Bus<7>") getData("/Input<0>") getData("/Input<1>") getData("/Input<2>") getData("/Input<3>") getData("/Input<4>") getData("/Input<5>") getData("/Input<6>") getData("/Input<7>") )
modelFile(
    '("/project/linuxlab/cadence/CDK/ncsu/models/spectre/nom/ami06N.m" "")
    '("/project/linuxlab/cadence/CDK/ncsu/models/spectre/nom/ami06P.m" "")
)
run()
selectResult( 'tran )
plot(getData("/I14/I87/net13") getData("/I14/net74") getData("/Input<0>") getData("/Input<1>") getData("/Input<2>") getData("/Input<3>") getData("/Input<4>") getData("/Input<5>") getData("/Input<6>") getData("/Input<7>") getData("/Bus<0>") getData("/Bus<1>") getData("/Bus<2>") getData("/Bus<3>") getData("/Bus<4>") getData("/Bus<5>") getData("/Bus<6>") getData("/Bus<7>") )
modelFile(
    '("/project/linuxlab/cadence/CDK/ncsu/models/spectre/nom/ami06N.m" "")
    '("/project/linuxlab/cadence/CDK/ncsu/models/spectre/nom/ami06P.m" "")
)
run()
selectResult( 'tran )
plot(getData("/I14/I87/net13") getData("/I14/net74") getData("/Input<0>") getData("/Input<1>") getData("/Input<2>") getData("/Input<3>") getData("/Input<4>") getData("/Input<5>") getData("/Input<6>") getData("/Input<7>") getData("/Bus<0>") getData("/Bus<1>") getData("/Bus<2>") getData("/Bus<3>") getData("/Bus<4>") getData("/Bus<5>") getData("/Bus<6>") getData("/Bus<7>") )
modelFile(
    '("/project/linuxlab/cadence/CDK/ncsu/models/spectre/nom/ami06N.m" "")
    '("/project/linuxlab/cadence/CDK/ncsu/models/spectre/nom/ami06P.m" "")
)
run()
selectResult( 'tran )
plot(getData("/I14/I87/net13") getData("/I14/net74") getData("/Input<0>") getData("/Input<1>") getData("/Input<2>") getData("/Input<3>") getData("/Input<4>") getData("/Input<5>") getData("/Input<6>") getData("/Input<7>") getData("/Bus<0>") getData("/Bus<1>") getData("/Bus<2>") getData("/Bus<3>") getData("/Bus<4>") getData("/Bus<5>") getData("/Bus<6>") getData("/Bus<7>") )
modelFile(
    '("/project/linuxlab/cadence/CDK/ncsu/models/spectre/nom/ami06N.m" "")
    '("/project/linuxlab/cadence/CDK/ncsu/models/spectre/nom/ami06P.m" "")
)
run()
selectResult( 'tran )
plot(getData("/I14/net74") getData("/I14/I87/inv_out") getData("/Input<0>") getData("/Input<1>") getData("/Input<2>") getData("/Input<3>") getData("/Input<4>") getData("/Input<5>") getData("/Input<6>") getData("/Input<7>") getData("/Bus<0>") getData("/Bus<1>") getData("/Bus<2>") getData("/Bus<3>") getData("/Bus<4>") getData("/Bus<5>") getData("/Bus<6>") getData("/Bus<7>") )
modelFile(
    '("/project/linuxlab/cadence/CDK/ncsu/models/spectre/nom/ami06N.m" "")
    '("/project/linuxlab/cadence/CDK/ncsu/models/spectre/nom/ami06P.m" "")
)
run()
selectResult( 'tran )
plot(getData("/I14/I60/net13") getData("/Input<0>") getData("/Input<1>") getData("/Input<2>") getData("/Input<3>") getData("/Input<4>") getData("/Input<5>") getData("/Input<6>") getData("/Input<7>") getData("/Bus<0>") getData("/Bus<1>") getData("/Bus<2>") getData("/Bus<3>") getData("/Bus<4>") getData("/Bus<5>") getData("/Bus<6>") getData("/Bus<7>") getData("/I14/I87/inv_out") getData("/I14/net74") )
modelFile(
    '("/project/linuxlab/cadence/CDK/ncsu/models/spectre/nom/ami06N.m" "")
    '("/project/linuxlab/cadence/CDK/ncsu/models/spectre/nom/ami06P.m" "")
)
run()
selectResult( 'tran )
plot(getData("/F1") getData("/F2") getData("/Input<0>") getData("/Bus<0>") )
modelFile(
    '("/project/linuxlab/cadence/CDK/ncsu/models/spectre/nom/ami06N.m" "")
    '("/project/linuxlab/cadence/CDK/ncsu/models/spectre/nom/ami06P.m" "")
)
run()
selectResult( 'tran )
plot(getData("/I14/I60/net13") getData("/Input<0>") getData("/Bus<0>") getData("/F2") getData("/F1") )
modelFile(
    '("/project/linuxlab/cadence/CDK/ncsu/models/spectre/nom/ami06N.m" "")
    '("/project/linuxlab/cadence/CDK/ncsu/models/spectre/nom/ami06P.m" "")
)
run()
selectResult( 'tran )
plot(getData("/Input<0>") getData("/Bus<0>") getData("/F2") getData("/F1") getData("/I14/I60/net13") )
