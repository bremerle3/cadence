// Design: cse562/new_squarer
simulator lang=spectre
global 0 vdd!
parameters nW=2.4u nL=2u pW=2.4u pL=2u
include "/project/linuxlab/cadence/CDK/ncsu/models/spectre/nom/ami06N.m"
include "/project/linuxlab/cadence/CDK/ncsu/models/spectre/nom/ami06P.m"

// cse562/new_squarer/schematic
V0 (vdd! 0) vsource type=dc dc=3
I13 (net21 0) isource type=dc dc=60n m=1
I5 (0 net2) isource type=dc dc=50n m=1
N2 (net6 net2 0 0) ami06N w=nW l=nL m=1 region=sat
N0 (net3 net2 0 0) ami06N w=nW l=nL m=1 region=sat
N1 (net2 net2 0 0) ami06N w=nW l=nL m=1 region=sat
P7 (net21 net21 vdd! vdd!) ami06P w=pW l=pL m=1 region=sat
P6 (net19 net21 vdd! vdd!) ami06P w=pW l=pL m=1 region=sat
I_o (0 net6 net19 vdd!) ami06P w=pW l=pL m=1 region=sat
I_2 (0 net6 net5 vdd!) ami06P w=pW l=pL m=1 region=sat
I_Out (0 net19 vdd! vdd!) ami06P w=pW l=pL m=1 region=sat
I_1 (net6 net5 vdd! vdd!) ami06P w=pW l=pL m=1 region=sat
P1 (net5 net3 vdd! vdd!) ami06P w=pW l=pL m=1 region=sat
P0 (net3 net3 vdd! vdd!) ami06P w=pW l=pL m=1 region=sat
simulatorOptions options temp=27
dcOp dc
dc dc dev=I5 param=dc start=0 stop=100n
save I_Out:d
