simulator( 'spectre )
design(	 "/home/warehouse/lbremer/cadence/simulation/8_bit_reg_v1_test/spectre/schematic/netlist/netlist")
resultsDir( "/home/warehouse/lbremer/cadence/simulation/8_bit_reg_v1_test/spectre/schematic" )
modelFile(
    '("/project/linuxlab/cadence/CDK/ncsu/models/spectre/nom/ami06N.m" "")
    '("/project/linuxlab/cadence/CDK/ncsu/models/spectre/nom/ami06P.m" "")
)
analysis('tran ?stop "2u"  )
envOption(
	'analysisOrder  list("tran")
)
temp( 27 )
run()
selectResult( 'tran )
plot(getData("/F2") getData("/F1") getData("/S0") getData("/S1") getData("/Out0") getData("/Out1") getData("/Out2") getData("/Out3") getData("/Out4") getData("/Out5") getData("/Out6") getData("/Out7") )
modelFile(
    '("/project/linuxlab/cadence/CDK/ncsu/models/spectre/nom/ami06N.m" "")
    '("/project/linuxlab/cadence/CDK/ncsu/models/spectre/nom/ami06P.m" "")
)
run()
selectResult( 'tran )
plot(getData("/F2") getData("/F1") getData("/S0") getData("/S1") getData("/Out0") getData("/Out1") getData("/Out2") getData("/Out3") getData("/Out4") getData("/Out5") getData("/Out6") getData("/Out7") )
modelFile(
    '("/project/linuxlab/cadence/CDK/ncsu/models/spectre/nom/ami06N.m" "")
    '("/project/linuxlab/cadence/CDK/ncsu/models/spectre/nom/ami06P.m" "")
)
run()
selectResult( 'tran )
plot(getData("/Out0") getData("/Out1") getData("/Out2") getData("/Out3") getData("/Out4") getData("/Out5") getData("/Out6") getData("/Out7") getData("/S1") getData("/S0") getData("/F1") getData("/F2") )
modelFile(
    '("/project/linuxlab/cadence/CDK/ncsu/models/spectre/nom/ami06N.m" "")
    '("/project/linuxlab/cadence/CDK/ncsu/models/spectre/nom/ami06P.m" "")
)
run()
selectResult( 'tran )
plot(getData("/Out0") getData("/Out1") getData("/Out2") getData("/Out3") getData("/Out4") getData("/Out5") getData("/Out6") getData("/Out7") getData("/S1") getData("/S0") getData("/F1") getData("/F2") )
modelFile(
    '("/project/linuxlab/cadence/CDK/ncsu/models/spectre/nom/ami06N.m" "")
    '("/project/linuxlab/cadence/CDK/ncsu/models/spectre/nom/ami06P.m" "")
)
run()
selectResult( 'tran )
plot(getData("/Out7") getData("/S1") getData("/S0") getData("/F1") getData("/F2") )
modelFile(
    '("/project/linuxlab/cadence/CDK/ncsu/models/spectre/nom/ami06N.m" "")
    '("/project/linuxlab/cadence/CDK/ncsu/models/spectre/nom/ami06P.m" "")
)
run()
selectResult( 'tran )
plot(getData("/Load") getData("/Out7") getData("/S1") getData("/S0") getData("/F1") getData("/F2") )
