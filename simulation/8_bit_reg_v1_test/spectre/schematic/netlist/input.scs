// Design: cse463_project/8_bit_reg_v1_test
simulator lang=spectre
global 0 vdd!
include "/project/linuxlab/cadence/CDK/ncsu/models/spectre/nom/ami06N.m"
include "/project/linuxlab/cadence/CDK/ncsu/models/spectre/nom/ami06P.m"

// cse463_project/min_inv/schematic
subckt min_inv In out
    N0 (out In 0 0) ami06N w=900n l=600n m=1 region=sat
    P0 (out In vdd! vdd!) ami06P w=900n l=600n m=1 region=sat
ends min_inv

// cse463_project/d_flip_flop/schematic
subckt d_flip_flop D F1 F2 Q
    N3 (net2 F2 net5 0) ami06N w=900n l=600n m=1 region=sat
    N2 (net1 F1 D 0) ami06N w=900n l=600n m=1 region=sat
    N1 (net2 F1 net6 0) ami06N w=900n l=600n m=1 region=sat
    N0 (net1 F2 net4 0) ami06N w=900n l=600n m=1 region=sat
    I10 (Q net6) min_inv
    I9 (net5 net4) min_inv
    I8 (net2 Q) min_inv
    I7 (net1 net5) min_inv
ends d_flip_flop

// cse463_project/3_1_mux/schematic
subckt cse463_project_3_1_mux_schematic Hold Load Out S0 S1 inh_inh_bn
    M3 (net19 S1 0 gnd!) ami06N w=900n l=600n m=1 region=sat
    M2 (Out S0 net17 gnd!) ami06N w=900n l=600n m=1 region=sat
    M1 (Out S0 net18 gnd!) ami06N w=900n l=600n m=1 region=sat
    M0 (net18 S1 Hold gnd!) ami06N w=900n l=600n m=1 region=sat
    M5 (net19 S0 Out vdd!) ami06P w=900n l=600n m=1 region=sat
    M4 (Load S1 net17 vdd!) ami06P w=900n l=600n m=1 region=sat
ends cse463_project_3_1_mux_schematic

// cse463_project/single_muxed_ff/schematic
subckt single_muxed_ff F1 F2 Load Out S0 S1 inh_inh_bn
    I0 (net13 F1 F2 Out) d_flip_flop
    I1 (Out Load net13 S0 S1 inh_inh_bn) cse463_project_3_1_mux_schematic
ends single_muxed_ff

// cse463_project/8_bit_reg_v1/schematic
subckt cse463_project_8_bit_reg_v1_schematic F1 F2 In0 In1 In2 In3 In4 In5 In6 In7 Out0 Out1 Out2 Out3 Out4 Out5 Out6 Out7 S0 S1 inh_inh_bn
    I56 (F1 F2 In4 Out4 S0 S1 inh_inh_bn) single_muxed_ff
    I55 (F1 F2 In5 Out5 S0 S1 inh_inh_bn) single_muxed_ff
    I54 (F1 F2 In6 Out6 S0 S1 inh_inh_bn) single_muxed_ff
    I53 (F1 F2 In7 Out7 S0 S1 inh_inh_bn) single_muxed_ff
    I52 (F1 F2 In2 Out2 S0 S1 inh_inh_bn) single_muxed_ff
    I51 (F1 F2 In3 Out3 S0 S1 inh_inh_bn) single_muxed_ff
    I44 (F1 F2 In1 Out1 S0 S1 inh_inh_bn) single_muxed_ff
    I43 (F1 F2 In0 Out0 S0 S1 inh_inh_bn) single_muxed_ff
ends cse463_project_8_bit_reg_v1_schematic

// cse463_project/8_bit_reg_v1_test/schematic
I0 (F1 F2 Load Load Load Load Load Load Load Load Out0 Out1 Out2 Out3 Out4 Out5 Out6 Out7 S0 S1 0) cse463_project_8_bit_reg_v1_schematic
V0 (Load 0) vsource type=pulse val0=5 val1=0 period=200n width=100n
V3 (F2 0) vsource type=pulse val0=0 val1=5 period=100n delay=62.5n width=25n
V2 (F1 0) vsource type=pulse val0=0 val1=5 period=100n width=50n
V5 (S0 0) vsource type=pulse val0=0 val1=5 period=600n delay=100n width=300n
V4 (S1 0) vsource type=pulse val0=0 val1=5 period=400n width=200n
C11 (Out0 0) capacitor c=100f m=1
C10 (Out1 0) capacitor c=100f m=1
C9 (Out2 0) capacitor c=100f m=1
C8 (Out3 0) capacitor c=100f m=1
C6 (Out4 0) capacitor c=100f m=1
C4 (Out5 0) capacitor c=100f m=1
C2 (Out6 0) capacitor c=100f m=1
C0 (Out7 0) capacitor c=100f m=1
V1 (vdd! 0) vsource type=dc dc=5
simulatorOptions options temp=27
tran tran stop=2u
