simulator( 'spectre )
design(	 "/home/warehouse/lbremer/cadence/simulation/latch_no_sym/spectre/schematic/netlist/netlist")
resultsDir( "/home/warehouse/lbremer/cadence/simulation/latch_no_sym/spectre/schematic" )
modelFile(
    '("/project/linuxlab/cadence/CDK/ncsu/models/spectre/nom/ami06N.m" "")
    '("/project/linuxlab/cadence/CDK/ncsu/models/spectre/nom/ami06P.m" "")
)
analysis('tran ?stop "96u"  )
envOption(
	'analysisOrder  list("tran")
)
temp( 27 )
run()
selectResult( 'tran )
plot(getData("/net4") getData("/net6") getData("/net24") )
modelFile(
    '("/project/linuxlab/cadence/CDK/ncsu/models/spectre/nom/ami06N.m" "")
    '("/project/linuxlab/cadence/CDK/ncsu/models/spectre/nom/ami06P.m" "")
)
desVar(	  "pL" 600n	)
desVar(	  "pW" 900n	)
desVar(	  "nL" 600n	)
desVar(	  "nW" 900n	)
run()
selectResult( 'tran )
plot(getData("/net4") getData("/net6") getData("/net24") )
modelFile(
    '("/project/linuxlab/cadence/CDK/ncsu/models/spectre/nom/ami06N.m" "")
    '("/project/linuxlab/cadence/CDK/ncsu/models/spectre/nom/ami06P.m" "")
)
run()
selectResult( 'tran )
plot(getData("/net24") getData("/net6") getData("/net4") )
modelFile(
    '("/project/linuxlab/cadence/CDK/ncsu/models/spectre/nom/ami06N.m" "")
    '("/project/linuxlab/cadence/CDK/ncsu/models/spectre/nom/ami06P.m" "")
)
run()
selectResult( 'tran )
plot(getData("/net24") getData("/net6") getData("/net4") )
modelFile(
    '("/project/linuxlab/cadence/CDK/ncsu/models/spectre/nom/ami06N.m" "")
    '("/project/linuxlab/cadence/CDK/ncsu/models/spectre/nom/ami06P.m" "")
)
run()
selectResult( 'tran )
plot(getData("/net24") getData("/net6") getData("/net4") )
modelFile(
    '("/project/linuxlab/cadence/CDK/ncsu/models/spectre/nom/ami06N.m" "")
    '("/project/linuxlab/cadence/CDK/ncsu/models/spectre/nom/ami06P.m" "")
)
run()
selectResult( 'tran )
plot(getData("/net24") getData("/net6") getData("/net4") )
modelFile(
    '("/project/linuxlab/cadence/CDK/ncsu/models/spectre/nom/ami06N.m" "")
    '("/project/linuxlab/cadence/CDK/ncsu/models/spectre/nom/ami06P.m" "")
)
analysis('tran ?stop "60n"  )
run()
selectResult( 'tran )
plot(getData("/net24") getData("/net6") getData("/net4") )
modelFile(
    '("/project/linuxlab/cadence/CDK/ncsu/models/spectre/nom/ami06N.m" "")
    '("/project/linuxlab/cadence/CDK/ncsu/models/spectre/nom/ami06P.m" "")
)
run()
selectResult( 'tran )
plot(getData("/net24") getData("/net6") getData("/net4") )
modelFile(
    '("/project/linuxlab/cadence/CDK/ncsu/models/spectre/nom/ami06N.m" "")
    '("/project/linuxlab/cadence/CDK/ncsu/models/spectre/nom/ami06P.m" "")
)
run()
selectResult( 'tran )
plot(getData("/net24") getData("/net6") getData("/net4") )
modelFile(
    '("/project/linuxlab/cadence/CDK/ncsu/models/spectre/nom/ami06N.m" "")
    '("/project/linuxlab/cadence/CDK/ncsu/models/spectre/nom/ami06P.m" "")
)
analysis('tran ?stop "96n"  )
run()
selectResult( 'tran )
plot(getData("/net24") getData("/net6") getData("/net4") )
modelFile(
    '("/project/linuxlab/cadence/CDK/ncsu/models/spectre/nom/ami06N.m" "")
    '("/project/linuxlab/cadence/CDK/ncsu/models/spectre/nom/ami06P.m" "")
)
run()
selectResult( 'tran )
plot(getData("/net24") getData("/net6") getData("/net4") )
modelFile(
    '("/project/linuxlab/cadence/CDK/ncsu/models/spectre/nom/ami06N.m" "")
    '("/project/linuxlab/cadence/CDK/ncsu/models/spectre/nom/ami06P.m" "")
)
run()
selectResult( 'tran )
plot(getData("/net24") getData("/net6") getData("/net4") )
modelFile(
    '("/project/linuxlab/cadence/CDK/ncsu/models/spectre/nom/ami06N.m" "")
    '("/project/linuxlab/cadence/CDK/ncsu/models/spectre/nom/ami06P.m" "")
)
run()
selectResult( 'tran )
plot(getData("/net24") getData("/net6") getData("/net4") )
modelFile(
    '("/project/linuxlab/cadence/CDK/ncsu/models/spectre/nom/ami06N.m" "")
    '("/project/linuxlab/cadence/CDK/ncsu/models/spectre/nom/ami06P.m" "")
)
run()
selectResult( 'tran )
plot(getData("/net24") getData("/net6") getData("/net4") )
modelFile(
    '("/project/linuxlab/cadence/CDK/ncsu/models/spectre/nom/ami06N.m" "")
    '("/project/linuxlab/cadence/CDK/ncsu/models/spectre/nom/ami06P.m" "")
)
analysis('tran ?stop "96u"  )
run()
selectResult( 'tran )
plot(getData("/net24") getData("/net6") getData("/net4") )
modelFile(
    '("/project/linuxlab/cadence/CDK/ncsu/models/spectre/nom/ami06N.m" "")
    '("/project/linuxlab/cadence/CDK/ncsu/models/spectre/nom/ami06P.m" "")
)
run()
selectResult( 'tran )
plot(getData("/net24") getData("/net6") getData("/net4") )
modelFile(
    '("/project/linuxlab/cadence/CDK/ncsu/models/spectre/nom/ami06N.m" "")
    '("/project/linuxlab/cadence/CDK/ncsu/models/spectre/nom/ami06P.m" "")
)
run()
selectResult( 'tran )
plot(getData("/net24") getData("/net6") getData("/net4") )
modelFile(
    '("/project/linuxlab/cadence/CDK/ncsu/models/spectre/nom/ami06N.m" "")
    '("/project/linuxlab/cadence/CDK/ncsu/models/spectre/nom/ami06P.m" "")
)
run()
selectResult( 'tran )
plot(getData("/net24") getData("/net6") getData("/net4") )
modelFile(
    '("/project/linuxlab/cadence/CDK/ncsu/models/spectre/nom/ami06N.m" "")
    '("/project/linuxlab/cadence/CDK/ncsu/models/spectre/nom/ami06P.m" "")
)
run()
selectResult( 'tran )
plot(getData("/net24") getData("/net6") getData("/net4") )
modelFile(
    '("/project/linuxlab/cadence/CDK/ncsu/models/spectre/nom/ami06N.m" "")
    '("/project/linuxlab/cadence/CDK/ncsu/models/spectre/nom/ami06P.m" "")
)
run()
selectResult( 'tran )
plot(getData("/net24") getData("/net6") getData("/net4") )
modelFile(
    '("/project/linuxlab/cadence/CDK/ncsu/models/spectre/nom/ami06N.m" "")
    '("/project/linuxlab/cadence/CDK/ncsu/models/spectre/nom/ami06P.m" "")
)
run()
selectResult( 'tran )
plot(getData("/net24") getData("/net6") getData("/net4") )
modelFile(
    '("/project/linuxlab/cadence/CDK/ncsu/models/spectre/nom/ami06N.m" "")
    '("/project/linuxlab/cadence/CDK/ncsu/models/spectre/nom/ami06P.m" "")
)
run()
selectResult( 'tran )
plot(getData("/net24") getData("/net6") getData("/net4") )
modelFile(
    '("/project/linuxlab/cadence/CDK/ncsu/models/spectre/nom/ami06N.m" "")
    '("/project/linuxlab/cadence/CDK/ncsu/models/spectre/nom/ami06P.m" "")
)
run()
selectResult( 'tran )
plot(getData("/net24") getData("/net6") getData("/net4") )
modelFile(
    '("/project/linuxlab/cadence/CDK/ncsu/models/spectre/nom/ami06N.m" "")
    '("/project/linuxlab/cadence/CDK/ncsu/models/spectre/nom/ami06P.m" "")
)
run()
selectResult( 'tran )
plot(getData("/net24") getData("/net6") getData("/net4") )
modelFile(
    '("/project/linuxlab/cadence/CDK/ncsu/models/spectre/nom/ami06N.m" "")
    '("/project/linuxlab/cadence/CDK/ncsu/models/spectre/nom/ami06P.m" "")
)
run()
selectResult( 'tran )
plot(getData("/net24") getData("/net6") getData("/net4") )
modelFile(
    '("/project/linuxlab/cadence/CDK/ncsu/models/spectre/nom/ami06N.m" "")
    '("/project/linuxlab/cadence/CDK/ncsu/models/spectre/nom/ami06P.m" "")
)
desVar(	  "pL" 360n	)
desVar(	  "pW" 180n	)
desVar(	  "nL" 360n	)
desVar(	  "nW" .18u	)
run()
selectResult( 'tran )
plot(getData("/net24") getData("/net6") getData("/net4") )
modelFile(
    '("/project/linuxlab/cadence/CDK/ncsu/models/spectre/nom/ami06N.m" "")
    '("/project/linuxlab/cadence/CDK/ncsu/models/spectre/nom/ami06P.m" "")
)
desVar(	  "pL" 180n	)
desVar(	  "pW" 360n	)
desVar(	  "nL" 180n	)
desVar(	  "nW" .36	)
run()
selectResult( 'tran )
plot(getData("/net24") getData("/net6") getData("/net4") )
modelFile(
    '("/project/linuxlab/cadence/CDK/ncsu/models/spectre/nom/ami06N.m" "")
    '("/project/linuxlab/cadence/CDK/ncsu/models/spectre/nom/ami06P.m" "")
)
desVar(	  "nW" 360n	)
run()
selectResult( 'tran )
plot(getData("/net24") getData("/net6") getData("/net4") )
modelFile(
    '("/project/linuxlab/cadence/CDK/ncsu/models/spectre/nom/ami06N.m" "")
    '("/project/linuxlab/cadence/CDK/ncsu/models/spectre/nom/ami06P.m" "")
)
desVar(	  "pL" 600n	)
desVar(	  "pW" 900n	)
desVar(	  "nL" 600	)
desVar(	  "nW" 900n	)
run()
selectResult( 'tran )
plot(getData("/net24") getData("/net6") getData("/net4") )
modelFile(
    '("/project/linuxlab/cadence/CDK/ncsu/models/spectre/nom/ami06N.m" "")
    '("/project/linuxlab/cadence/CDK/ncsu/models/spectre/nom/ami06P.m" "")
)
desVar(	  "nL" 600n	)
run()
selectResult( 'tran )
plot(getData("/net24") getData("/net6") getData("/net4") )
modelFile(
    '("/project/linuxlab/cadence/CDK/ncsu/models/spectre/nom/ami06N.m" "")
    '("/project/linuxlab/cadence/CDK/ncsu/models/spectre/nom/ami06P.m" "")
)
desVar(	  "pL" 180n	)
desVar(	  "pW" 360n	)
desVar(	  "nL" 180n	)
desVar(	  "nW" 360n	)
run()
selectResult( 'tran )
plot(getData("/net24") getData("/net6") getData("/net4") )
modelFile(
    '("/project/linuxlab/cadence/CDK/ncsu/models/spectre/nom/ami06N.m" "")
    '("/project/linuxlab/cadence/CDK/ncsu/models/spectre/nom/ami06P.m" "")
)
desVar(	  "pL" 600n	)
desVar(	  "pW" 900n	)
desVar(	  "nL" 600n	)
desVar(	  "nW" 900n	)
run()
modelFile(
    '("/project/linuxlab/cadence/CDK/ncsu/models/spectre/nom/ami06N.m" "")
    '("/project/linuxlab/cadence/CDK/ncsu/models/spectre/nom/ami06P.m" "")
)
run()
modelFile(
    '("/project/linuxlab/cadence/CDK/ncsu/models/spectre/nom/ami06N.m" "")
    '("/project/linuxlab/cadence/CDK/ncsu/models/spectre/nom/ami06P.m" "")
)
run()
selectResult( 'tran )
plot(getData("/net24") getData("/net6") getData("/net4") )
modelFile(
    '("/project/linuxlab/cadence/CDK/ncsu/models/spectre/nom/ami06N.m" "")
    '("/project/linuxlab/cadence/CDK/ncsu/models/spectre/nom/ami06P.m" "")
)
run()
selectResult( 'tran )
plot(getData("/net4") getData("/net6") getData("/net24") )
modelFile(
    '("/project/linuxlab/cadence/CDK/ncsu/models/spectre/nom/ami06N.m" "")
    '("/project/linuxlab/cadence/CDK/ncsu/models/spectre/nom/ami06P.m" "")
)
run()
selectResult( 'tran )
plot(getData("/net4") getData("/net6") getData("/net24") )
