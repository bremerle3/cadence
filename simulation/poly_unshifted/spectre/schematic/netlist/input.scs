// Design: cse562/poly_unshifted
simulator lang=spectre
global 0 vdd!
parameters pW=2.4u pL=2u nW=2.4u nL=2u
include "/project/linuxlab/cadence/CDK/ncsu/models/spectre/nom/ami06N.m"
include "/project/linuxlab/cadence/CDK/ncsu/models/spectre/nom/ami06P.m"

// cse562/squarer/schematic
subckt squarer I_In I_Out I_o Squared
    M4 (0 I_Out I_o vdd!) ami06P w=pW l=pL m=1 region=sat
    M1 (0 I_Out I_In vdd!) ami06P w=pW l=pL m=1 region=sat
    M3 (Squared I_o vdd! vdd!) ami06P w=pW l=pL m=1 region=sat
    M2 (I_Out I_In vdd! vdd!) ami06P w=pW l=pL m=1 region=sat
ends squarer

// cse562/poly_unshifted/schematic
Input (0 net1) isource type=dc m=1
Bias (net6 0) isource type=dc dc=60n m=1
N2 (net28 net1 0 0) ami06N w=nW l=nL m=1 region=sat
N3 (net35 net1 0 0) ami06N w=nW l=nL m=1 region=sat
N1 (net10 net1 0 0) ami06N w=nW l=nL m=1 region=sat
N0 (net1 net1 0 0) ami06N w=nW l=nL m=1 region=sat
N5 (net11 net11 0 0) ami06N w=nW l=nL m=1 region=sat
N6 (net13 net11 0 0) ami06N w=nW l=nL m=1 region=sat
N15 (net26 net19 0 0) ami06N w=nW l=nL m=1 region=sat
N12 (net19 net19 0 0) ami06N w=nW l=nL m=1 region=sat
N16 (net26 net26 0 0) ami06N w=nW l=nL m=1 region=sat
V0 (vdd! 0) vsource type=dc dc=3
P10 (net13 net13 vdd! vdd!) ami06P w=pW l=pL m=1 region=sat
P11 (net32 net13 vdd! vdd!) ami06P w=pW l=pL m=1 region=sat
P20 (net19 net13 vdd! vdd!) ami06P w=pW l=2*pL m=1 region=sat
P14 (net19 net13 vdd! vdd!) ami06P w=pW l=2*pL m=1 region=sat
P19 (net19 net13 vdd! vdd!) ami06P w=pW l=2*pL m=1 region=sat
P1 (net43 net10 vdd! vdd!) ami06P w=pW l=pL m=1 region=sat
P15 (net26 net10 vdd! vdd!) ami06P w=pW l=2*pL m=1 region=sat
P0 (net10 net10 vdd! vdd!) ami06P w=pW l=pL m=1 region=sat
P5 (net31 net6 vdd! vdd!) ami06P w=pW l=pL m=1 region=sat
P3 (net6 net6 vdd! vdd!) ami06P w=pW l=pL m=1 region=sat
P2 (net24 net6 vdd! vdd!) ami06P w=pW l=pL m=1 region=sat
P4 (0 net26 net26 vdd!) ami06P w=pW l=pL m=1 region=sat
I13 (net43 net28 net24 net11) squarer
I8 (net32 net35 net31 net26) squarer
simulatorOptions options temp=27
dcOp dc
dc dc dev=Input param=dc start=0n stop=60n
save P15:d I8:4 N15:d
