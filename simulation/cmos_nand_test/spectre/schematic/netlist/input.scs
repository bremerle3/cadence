// Design: 563_final/cmos_nand_test
simulator lang=spectre
global 0 vdd!
parameters Vin2=0 Vin1=0
include "/project/linuxlab/cadence/CDK/ncsu/models/spectre/nom/ami06N.m"
include "/project/linuxlab/cadence/CDK/ncsu/models/spectre/nom/ami06P.m"

// 563_final/cmos_nand/schematic
subckt cmos_nand Vin1 Vin2 Vout
    N3 (Vout Vin2 0 0) ami06N w=1.2u l=600n m=1 region=sat
    N2 (Vout Vin1 0 0) ami06N w=1.2u l=600n m=1 region=sat
    P3 (Vout Vin2 net14 vdd!) ami06P w=14.4u l=600n m=1 region=sat
    P2q (net14 Vin1 vdd! vdd!) ami06P w=14.4u l=600n m=1 region=sat
ends cmos_nand

// 563_final/cmos_nand_test/schematic
I6 (net1 net3 net2) cmos_nand
C0 (net2 0) capacitor c=1f m=1
V2 (net3 0) vsource type=dc dc=Vin2
V0 (vdd! 0) vsource type=dc dc=5
V1 (net1 0) vsource type=dc dc=Vin1
simulatorOptions options temp=27
dcOp dc
dc dc dev=V1 param=dc start=0 stop=5
