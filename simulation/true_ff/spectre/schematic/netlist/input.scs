// Design: cse562/true_ff
simulator lang=spectre
global 0 vdd!
parameters nW=900n nL=600n pW=900n pL=600n
include "/project/linuxlab/cadence/CDK/ncsu/models/spectre/nom/ami06N.m"
include "/project/linuxlab/cadence/CDK/ncsu/models/spectre/nom/ami06P.m"

// cse562/true_ff/schematic
N6 (Q net7 0 0) ami06N w=nW l=nL m=1 region=sat
N5 (net19 net5 0 0) ami06N w=nW l=nL m=1 region=sat
N4 (net7 CLK net19 net19) ami06N w=nW l=nL m=1 region=sat
N3 (net5 net3 net15 net15) ami06N w=nW l=nL m=1 region=sat
N2 (net15 CLK 0 0) ami06N w=nW l=nL m=1 region=sat
N1 (net3 D 0 0) ami06N w=nW l=nL m=1 region=sat
P9 (Q net7 vdd! vdd!) ami06P w=pW l=pL m=1 region=sat
P7 (net7 net5 vdd! vdd!) ami06P w=pW l=pL m=1 region=sat
P5 (net5 CLK vdd! vdd!) ami06P w=pW l=pL m=1 region=sat
P4 (net3 CLK net10 net10) ami06P w=pW l=pL m=1 region=sat
P1 (net10 D vdd! vdd!) ami06P w=pW l=pL m=1 region=sat
simulatorOptions options temp=27
tran tran stop=32u
