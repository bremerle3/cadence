// Design: cse463_project/single_muxed_ff_test
simulator lang=spectre
global 0 vdd!
parameters W=1.8u
include "/project/linuxlab/cadence/CDK/ncsu/models/spectre/nom/ami06N.m"
include "/project/linuxlab/cadence/CDK/ncsu/models/spectre/nom/ami06P.m"

// cse463_project/min_inv/schematic
subckt min_inv In out
    N0 (out In 0 0) ami06N w=900n l=600n m=1 region=sat
    P0 (out In vdd! vdd!) ami06P w=900n l=600n m=1 region=sat
ends min_inv

// cse463_project/d_flip_flop/schematic
subckt d_flip_flop D F1 F2 Q
    N3 (net2 F2 net5 0) ami06N w=900n l=600n m=1 region=sat
    N2 (net1 F1 D 0) ami06N w=900n l=600n m=1 region=sat
    N1 (net2 F1 net6 0) ami06N w=900n l=600n m=1 region=sat
    N0 (net1 F2 net4 0) ami06N w=900n l=600n m=1 region=sat
    I10 (Q net6) min_inv
    I9 (net5 net4) min_inv
    I8 (net2 Q) min_inv
    I7 (net1 net5) min_inv
ends d_flip_flop

// cse463_project/3_1_mux_alt/schematic
subckt cse463_project_3_1_mux_alt_schematic Hold Load Out S0 S0B S1 S1B inh_inh_bn
    M5 (Out S0 net1 gnd!) ami06N w=900n l=600n m=1 region=sat
    M4 (net1 S1B 0 gnd!) ami06N w=900n l=600n m=1 region=sat
    M3 (Out S0B net2 gnd!) ami06N w=900n l=600n m=1 region=sat
    M2 (net2 S1 Load gnd!) ami06N w=900n l=600n m=1 region=sat
    M1 (Out S0 net3 gnd!) ami06N w=900n l=600n m=1 region=sat
    M0 (net3 S1 Hold gnd!) ami06N w=900n l=600n m=1 region=sat
ends cse463_project_3_1_mux_alt_schematic

// cse463_project/single_muxed_ff/schematic
subckt single_muxed_ff F1 F2 Load Out S0 S0B S1 S1B inh_inh_bn
    I0 (net13 F1 F2 Out) d_flip_flop
    I6 (Out Load net13 S0 S0B S1 S1B inh_inh_bn) cse463_project_3_1_mux_alt_schematic
ends single_muxed_ff

// cse463_project/IR_trigate/schematic
subckt IR_trigate inv_in N0 N0B N1 N1B Out inh_inh_bn
    M6 (Out N0B net12 gnd!) ami06N w=1.8u l=600n m=1 region=sat
    M5 (net12 N1B inv_out gnd!) ami06N w=1.8u l=600n m=1 region=sat
    I2 (inv_in net07) min_inv
    I1 (net07 inv_out) min_inv
    M1 (Out N0 net12 vdd!) ami06P w=1.8u l=600n m=1 region=sat
    M0 (net12 N1 inv_out vdd!) ami06P w=1.8u l=600n m=1 region=sat
ends IR_trigate

// cse463_project/single_muxed_ff_test/schematic
I7 (F1 F2 Load net018 S0 net8 S1 net6 0) single_muxed_ff
V3 (F2 0) vsource type=pulse val0=0 val1=5 period=100n delay=62.5n width=25n
V2 (F1 0) vsource type=pulse val0=0 val1=5 period=100n width=50n
V0 (Load 0) vsource type=pulse val0=5 val1=0 period=200n width=100n
V6 (S0 0) vsource type=dc dc=0
V5 (S1 0) vsource type=dc dc=5
V1 (vdd! 0) vsource type=dc dc=5
C0 (Out 0) capacitor c=100f m=1
I54 (S1 net6) min_inv
I55 (S0 net8) min_inv
I8 (net018 S0 S1 S0 S1 Out 0) IR_trigate
simulatorOptions options temp=27
tran tran stop=600n
