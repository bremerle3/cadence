simulator( 'spectre )
design(	 "/home/warehouse/lbremer/cadence/simulation/single_muxed_ff_test/spectre/schematic/netlist/netlist")
resultsDir( "/home/warehouse/lbremer/cadence/simulation/single_muxed_ff_test/spectre/schematic" )
modelFile(
    '("/project/linuxlab/cadence/CDK/ncsu/models/spectre/nom/ami06N.m" "")
    '("/project/linuxlab/cadence/CDK/ncsu/models/spectre/nom/ami06P.m" "")
)
analysis('tran ?stop "2u"  )
envOption(
	'analysisOrder  list("tran")
)
temp( 27 )
run()
selectResult( 'tran )
plot(getData("/Out") getData("/F2") getData("/F1") getData("/S0") getData("/S1") getData("/Load") )
