// Design: cse562/mirror2
simulator lang=spectre
global 0 vdd!
parameters nW=4u nL=4u pW=4u pL=4u
include "/project/linuxlab/cadence/CDK/ncsu/models/spectre/nom/ami06N.m"
include "/project/linuxlab/cadence/CDK/ncsu/models/spectre/nom/ami06P.m"

// cse562/mirror2/schematic
N3 (net010 net1 0 0) ami06N w=nW l=nL m=1 region=sat
N2 (net07 net1 0 0) ami06N w=3.15u l=nL m=1 region=sat
N1 (net03 net1 0 0) ami06N w=nW l=nL m=1 region=sat
N0 (net1 net1 0 0) ami06N w=nW l=nL m=1 region=sat
P4 (net010 net010 vdd! vdd!) ami06P w=pW l=pL m=1 region=sat
P3 (net07 net07 vdd! vdd!) ami06P w=pW l=pL m=1 region=sat
P2 (net03 net03 vdd! vdd!) ami06P w=pW l=pL m=1 region=sat
V0 (vdd! 0) vsource type=dc dc=3
I1 (vdd! net1) isource type=dc dc=50n m=1
simulatorOptions options temp=27
dcOp dc
dc dc dev=I1 param=dc start=0 stop=50n
save N0:s N1:s N2:s N3:s
