// Design: cse562/ota
simulator lang=spectre
global 0 vdd!
parameters nW=900n nL=600n pW=900n pL=600n
include "/project/linuxlab/cadence/CDK/ncsu/models/spectre/nom/ami06N.m"
include "/project/linuxlab/cadence/CDK/ncsu/models/spectre/nom/ami06P.m"

// cse562/comparator/schematic
subckt comparator V\+ V\- Vout
    I27 (vdd! net2) isource type=dc dc=200n m=1
    N2 (Vout net15 0 0) ami06N w=nW l=nL m=1 region=sat
    N1 (net15 V\+ net5 net5) ami06N w=nW l=nL m=1 region=sat
    N17 (net3 V\- net5 net5) ami06N w=nW l=nL m=1 region=sat
    N15 (net5 net2 net9 net9) ami06N w=nW l=nL m=1 region=sat
    N14 (net2 net2 net1 net1) ami06N w=nW l=nL m=1 region=sat
    N13 (net9 net1 0 0) ami06N w=nW l=nL m=1 region=sat
    N12 (net1 net1 0 0) ami06N w=nW l=nL m=1 region=sat
    P4 (net15 net3 vdd! vdd!) ami06P w=pW l=pL m=1 region=sat
    P5 (Vout net15 vdd! vdd!) ami06P w=pW l=pL m=1 region=sat
    P2 (net3 net3 vdd! vdd!) ami06P w=pW l=pL m=1 region=sat
ends comparator

// cse562/true_ff/schematic
subckt true_ff CLK D Q
    N6 (Q net7 0 0) ami06N w=nW l=nL m=1 region=sat
    N5 (net19 net5 0 0) ami06N w=nW l=nL m=1 region=sat
    N4 (net7 CLK net19 net19) ami06N w=nW l=nL m=1 region=sat
    N3 (net5 net3 net15 net15) ami06N w=nW l=nL m=1 region=sat
    N2 (net15 CLK 0 0) ami06N w=nW l=nL m=1 region=sat
    N1 (net3 D 0 0) ami06N w=nW l=nL m=1 region=sat
    P9 (Q net7 vdd! vdd!) ami06P w=pW l=pL m=1 region=sat
    P7 (net7 net5 vdd! vdd!) ami06P w=pW l=pL m=1 region=sat
    P5 (net5 CLK vdd! vdd!) ami06P w=pW l=pL m=1 region=sat
    P4 (net3 CLK net10 net10) ami06P w=pW l=pL m=1 region=sat
    P1 (net10 D vdd! vdd!) ami06P w=pW l=pL m=1 region=sat
ends true_ff

// cse562/ota/schematic
V1 (net11 0) vsource type=sine sinedc=2.5 ampl=2 freq=10K
N1 (net3 net05 0 0) ami06N w=nW l=nL m=1 region=sat
N0 (net05 net03 0 0) ami06N w=nW l=nL m=1 region=sat
N7 (net03 net6 0 0) ami06N w=nW l=nL m=1 region=sat
P1 (net3 net05 vdd! vdd!) ami06P w=pW l=pL m=1 region=sat
P0 (net05 net03 vdd! vdd!) ami06P w=pW l=pL m=1 region=sat
P8 (net03 net6 vdd! vdd!) ami06P w=pW l=pL m=1 region=sat
V4 (net06 0) vsource type=dc dc=2.5
V0 (vdd! 0) vsource type=dc dc=5
R1 (net11 net1) resistor r=500K m=1
R0 (net1 net3) resistor r=500K m=1
I42 (net1 net06 net10) comparator
I6 (net5 net10 net6) true_ff
C0 (net1 0) capacitor c=1p m=1
V2 (net5 0) vsource type=pulse val0=0 val1=5 period=125n rise=100.0f fall=100.0f width=62.5n
simulatorOptions options temp=27
tran tran stop=.1m
