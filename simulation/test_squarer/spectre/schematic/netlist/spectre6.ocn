simulator( 'spectre )
design(	 "/home/warehouse/lbremer/cadence/simulation/test_squarer/spectre/schematic/netlist/netlist")
resultsDir( "/home/warehouse/lbremer/cadence/simulation/test_squarer/spectre/schematic" )
modelFile(
    '("/project/linuxlab/cadence/CDK/ncsu/models/spectre/nom/ami06N.m" "")
    '("/project/linuxlab/cadence/CDK/ncsu/models/spectre/nom/ami06P.m" "")
)
analysis('dc ?saveOppoint t  ?dev "/Input"  ?param "dc"
		?start "0"  ?stop "60n"  )
envOption(
	'analysisOrder  list("dc")
)
save( 'i "/I13/Squared" )
temp( 27 )
run()
selectResult( 'dc )
plot(getData("/I13/Squared") )
modelFile(
    '("/project/linuxlab/cadence/CDK/ncsu/models/spectre/nom/ami06N.m" "")
    '("/project/linuxlab/cadence/CDK/ncsu/models/spectre/nom/ami06P.m" "")
)
desVar(	  "nL" 2u	)
desVar(	  "nW" 2.4u	)
desVar(	  "pL" 2u	)
desVar(	  "pW" 2.4u	)
run()
selectResult( 'dc )
plot(getData("/I13/Squared") )
modelFile(
    '("/project/linuxlab/cadence/CDK/ncsu/models/spectre/nom/ami06N.m" "")
    '("/project/linuxlab/cadence/CDK/ncsu/models/spectre/nom/ami06P.m" "")
)
analysis('dc ?stop "100n"  )
run()
selectResult( 'dc )
plot(getData("/I13/Squared") )
