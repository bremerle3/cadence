// Design: cse562/test_squarer
simulator lang=spectre
global 0 vdd!
parameters pW=2.4u pL=2u nW=2.4u nL=2u
include "/project/linuxlab/cadence/CDK/ncsu/models/spectre/nom/ami06N.m"
include "/project/linuxlab/cadence/CDK/ncsu/models/spectre/nom/ami06P.m"

// cse562/squarer/schematic
subckt squarer I_In I_Out I_o Squared
    M4 (0 I_Out I_o vdd!) ami06P w=pW l=pL m=1 region=sat
    M1 (0 I_Out I_In vdd!) ami06P w=pW l=pL m=1 region=sat
    M3 (Squared I_o vdd! vdd!) ami06P w=pW l=pL m=1 region=sat
    M2 (I_Out I_In vdd! vdd!) ami06P w=pW l=pL m=1 region=sat
ends squarer

// cse562/test_squarer/schematic
V0 (vdd! 0) vsource type=dc dc=3
I13 (net10 net7 net9 0) squarer
Bias (0 net9) isource type=dc dc=60n m=1
Input (0 net1) isource type=dc m=1
N2 (net7 net1 0 0) ami06N w=nW l=nL m=1 region=sat
N1 (net4 net1 0 0) ami06N w=nW l=nL m=1 region=sat
N0 (net1 net1 0 0) ami06N w=nW l=nL m=1 region=sat
P1 (net10 net4 vdd! vdd!) ami06P w=pW l=pL m=1 region=sat
P0 (net4 net4 vdd! vdd!) ami06P w=pW l=pL m=1 region=sat
simulatorOptions options temp=27
dcOp dc
dc dc dev=Input param=dc start=0 stop=100n
save I13:4
