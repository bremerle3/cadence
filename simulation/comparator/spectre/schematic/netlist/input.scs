// Design: cse562/comparator
simulator lang=spectre
global 0 vdd!
parameters nW=900n nL=600n pW=900n pL=600n
include "/project/linuxlab/cadence/CDK/ncsu/models/spectre/nom/ami06N.m"
include "/project/linuxlab/cadence/CDK/ncsu/models/spectre/nom/ami06P.m"

// cse562/comparator/schematic
C0 (net6 0) capacitor c=1p m=1
I27 (vdd! net2) isource type=dc dc=200n m=1
N2 (net6 net15 0 0) ami06N w=nW l=nL m=1 region=sat
N1 (net15 net19 net5 net5) ami06N w=nW l=nL m=1 region=sat
N17 (net3 net16 net5 net5) ami06N w=nW l=nL m=1 region=sat
N15 (net5 net2 net9 net9) ami06N w=nW l=nL m=1 region=sat
N14 (net2 net2 net1 net1) ami06N w=nW l=nL m=1 region=sat
N13 (net9 net1 0 0) ami06N w=nW l=nL m=1 region=sat
N12 (net1 net1 0 0) ami06N w=nW l=nL m=1 region=sat
V1 (net16 0) vsource type=dc dc=1.5
V2 (vdd! 0) vsource type=dc dc=3
P4 (net15 net3 vdd! vdd!) ami06P w=pW l=pL m=1 region=sat
P5 (net6 net15 vdd! vdd!) ami06P w=pW l=pL m=1 region=sat
P2 (net3 net3 vdd! vdd!) ami06P w=pW l=pL m=1 region=sat
V0 (net19 0) vsource type=pulse val0=200m val1=2.8 period=4u rise=2p fall=2p width=2u
simulatorOptions options temp=27
tran tran stop=8u
