// Design: cse563/nmos_threshold
simulator lang=spectre
global 0
parameters nW=900n nL=900n
include "/project/linuxlab/cadence/CDK/ncsu/models/spectre/nom/ami06N.m"
include "/project/linuxlab/cadence/CDK/ncsu/models/spectre/nom/ami06P.m"

// cse563/nmos_threshold/schematic
N0 (net2 net3 0 0) ami06N w=nW l=nL m=1 region=sat
V_ds (net2 0) vsource type=dc dc=5
V_gs (net3 0) vsource type=dc dc=2
simulatorOptions options temp=27
dcOp dc
dc dc dev=V_gs param=dc start=0 stop=2
save N0:d
