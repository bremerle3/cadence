// Design: cse562/proj1_opamp_test
simulator lang=spectre
global 0 vdd!
include "/project/linuxlab/cadence/CDK/ncsu/models/spectre/nom/ami06N.m"
include "/project/linuxlab/cadence/CDK/ncsu/models/spectre/nom/ami06P.m"

// cse562/proj1_opamp/schematic
subckt proj1_opamp Vin\+ Vin\- Vout
    P4 (net9 Vin\+ net12 vdd!) ami06P w=100.05u l=3u m=1 region=sat
    P3 (net8 Vin\- net9 vdd!) ami06P w=100.05u l=3u m=1 region=sat
    P2 (net9 net7 vdd! vdd!) ami06P w=100.05u l=3u m=1 region=sat
    P1 (Vout net7 vdd! vdd!) ami06P w=100.05u l=3u m=1 region=sat
    P0 (vdd! net7 net14 vdd!) ami06P w=100.05u l=3u m=1 region=sat
    N2 (Vout net12 0 0) ami06N w=100.05u l=3u m=1 region=sat
    N1 (net12 net8 0 0) ami06N w=100.05u l=3u m=1 region=sat
    N0 (0 net8 net8 0) ami06N w=100.05u l=3u m=1 region=sat
    I17 (net14 0) isource type=dc dc=1nA m=1
    C0 (Vout net12) capacitor c=10p m=1
ends proj1_opamp

// cse562/proj1_opamp_test/schematic
I0 (net4 net5 net3) proj1_opamp
V1 (net5 0) vsource type=dc dc=1.5
V0 (vdd! 0) vsource type=dc dc=3
V2 (net4 0) vsource type=pulse val0=0 val1=3 period=20n
simulatorOptions options temp=27
dcOp dc
dc dc dev=V2 param=dc start=1.45 stop=1.55
save I0:3
