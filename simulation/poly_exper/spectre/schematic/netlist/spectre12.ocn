simulator( 'spectre )
design(	 "/home/warehouse/lbremer/cadence/simulation/poly_exper/spectre/schematic/netlist/netlist")
resultsDir( "/home/warehouse/lbremer/cadence/simulation/poly_exper/spectre/schematic" )
modelFile(
    '("/project/linuxlab/cadence/CDK/ncsu/models/spectre/nom/ami06N.m" "")
    '("/project/linuxlab/cadence/CDK/ncsu/models/spectre/nom/ami06P.m" "")
)
analysis('dc ?saveOppoint t  ?dev "/Input"  ?param "dc"
		?start "0"  ?stop "60n"  )
envOption(
	'analysisOrder  list("dc")
)
save( 'i "/P15/D" "/I8/Squared" "/N15/D" )
temp( 27 )
run()
selectResult( 'dc )
plot(getData("/P15/D") getData("/I8/Squared") getData("/N15/D") )
modelFile(
    '("/project/linuxlab/cadence/CDK/ncsu/models/spectre/nom/ami06N.m" "")
    '("/project/linuxlab/cadence/CDK/ncsu/models/spectre/nom/ami06P.m" "")
)
desVar(	  "nL" 2u	)
desVar(	  "nW" 2.4u	)
desVar(	  "pL" 2u	)
desVar(	  "pW" 2.4u	)
run()
selectResult( 'dc )
plot(getData("/P15/D") getData("/I8/Squared") getData("/N15/D") )
modelFile(
    '("/project/linuxlab/cadence/CDK/ncsu/models/spectre/nom/ami06N.m" "")
    '("/project/linuxlab/cadence/CDK/ncsu/models/spectre/nom/ami06P.m" "")
)
run()
selectResult( 'dc )
plot(getData("/I8/Squared") getData("/P15/D") getData("/N15/D") )
modelFile(
    '("/project/linuxlab/cadence/CDK/ncsu/models/spectre/nom/ami06N.m" "")
    '("/project/linuxlab/cadence/CDK/ncsu/models/spectre/nom/ami06P.m" "")
)
run()
selectResult( 'dc )
plot(getData("/I8/Squared") getData("/P15/D") getData("/N15/D") )
modelFile(
    '("/project/linuxlab/cadence/CDK/ncsu/models/spectre/nom/ami06N.m" "")
    '("/project/linuxlab/cadence/CDK/ncsu/models/spectre/nom/ami06P.m" "")
)
save( 'i "/N7/D" "/N4/D" )
save( 'i /I8/Squared /P15/D )
run()
selectResult( 'dc )
plot(getData("/N7/D") getData("/N4/D") getData("/N15/D") )
modelFile(
    '("/project/linuxlab/cadence/CDK/ncsu/models/spectre/nom/ami06N.m" "")
    '("/project/linuxlab/cadence/CDK/ncsu/models/spectre/nom/ami06P.m" "")
)
save( 'i "/P4/D" )
save( 'i /N15/D )
run()
selectResult( 'dc )
plot(getData("/N7/D") getData("/N4/D") getData("/P4/D") )
modelFile(
    '("/project/linuxlab/cadence/CDK/ncsu/models/spectre/nom/ami06N.m" "")
    '("/project/linuxlab/cadence/CDK/ncsu/models/spectre/nom/ami06P.m" "")
)
save( 'i "/N12/D" )
run()
selectResult( 'dc )
plot(getData("/N7/D") getData("/N4/D") getData("/P4/D") getData("/N12/D") )
modelFile(
    '("/project/linuxlab/cadence/CDK/ncsu/models/spectre/nom/ami06N.m" "")
    '("/project/linuxlab/cadence/CDK/ncsu/models/spectre/nom/ami06P.m" "")
)
save( 'i "/N15/D" )
save( 'i /P4/D )
run()
selectResult( 'dc )
plot(getData("/N7/D") getData("/N4/D") getData("/N12/D") getData("/N15/D") )
modelFile(
    '("/project/linuxlab/cadence/CDK/ncsu/models/spectre/nom/ami06N.m" "")
    '("/project/linuxlab/cadence/CDK/ncsu/models/spectre/nom/ami06P.m" "")
)
save( 'i /N15/D )
run()
selectResult( 'dc )
plot(getData("/N7/D") getData("/N4/D") getData("/N12/D") )
modelFile(
    '("/project/linuxlab/cadence/CDK/ncsu/models/spectre/nom/ami06N.m" "")
    '("/project/linuxlab/cadence/CDK/ncsu/models/spectre/nom/ami06P.m" "")
)
run()
selectResult( 'dc )
plot(getData("/N7/D") getData("/N4/D") getData("/N12/D") )
modelFile(
    '("/project/linuxlab/cadence/CDK/ncsu/models/spectre/nom/ami06N.m" "")
    '("/project/linuxlab/cadence/CDK/ncsu/models/spectre/nom/ami06P.m" "")
)
save( 'i "/I21/gnd!" )
run()
selectResult( 'dc )
plot(getData("/N7/D") getData("/N4/D") getData("/N12/D") getData("/I21/gnd!") )
modelFile(
    '("/project/linuxlab/cadence/CDK/ncsu/models/spectre/nom/ami06N.m" "")
    '("/project/linuxlab/cadence/CDK/ncsu/models/spectre/nom/ami06P.m" "")
)
save( 'i "/P7/D" )
save( 'i /I21/gnd! )
run()
selectResult( 'dc )
plot(getData("/N7/D") getData("/N4/D") getData("/N12/D") getData("/P7/D") )
modelFile(
    '("/project/linuxlab/cadence/CDK/ncsu/models/spectre/nom/ami06N.m" "")
    '("/project/linuxlab/cadence/CDK/ncsu/models/spectre/nom/ami06P.m" "")
)
save( 'i "/N9/D" )
save( 'i /N4/D /N12/D /P7/D )
run()
selectResult( 'dc )
plot(getData("/N7/D") getData("/N9/D") )
modelFile(
    '("/project/linuxlab/cadence/CDK/ncsu/models/spectre/nom/ami06N.m" "")
    '("/project/linuxlab/cadence/CDK/ncsu/models/spectre/nom/ami06P.m" "")
)
save( 'i "/N4/D" )
save( 'i /N9/D )
run()
selectResult( 'dc )
plot(getData("/N7/D") getData("/N4/D") )
modelFile(
    '("/project/linuxlab/cadence/CDK/ncsu/models/spectre/nom/ami06N.m" "")
    '("/project/linuxlab/cadence/CDK/ncsu/models/spectre/nom/ami06P.m" "")
)
save( 'i "/N7/S" )
run()
selectResult( 'dc )
plot(getData("/N7/D") getData("/N4/D") getData("/N7/S") )
modelFile(
    '("/project/linuxlab/cadence/CDK/ncsu/models/spectre/nom/ami06N.m" "")
    '("/project/linuxlab/cadence/CDK/ncsu/models/spectre/nom/ami06P.m" "")
)
save( 'i "/N10/D" )
save( 'i /N7/S )
run()
selectResult( 'dc )
plot(getData("/N10/D") getData("/N7/D") getData("/N4/D") )
modelFile(
    '("/project/linuxlab/cadence/CDK/ncsu/models/spectre/nom/ami06N.m" "")
    '("/project/linuxlab/cadence/CDK/ncsu/models/spectre/nom/ami06P.m" "")
)
save( 'i "/N12/D" )
run()
selectResult( 'dc )
plot(getData("/N10/D") getData("/N12/D") )
modelFile(
    '("/project/linuxlab/cadence/CDK/ncsu/models/spectre/nom/ami06N.m" "")
    '("/project/linuxlab/cadence/CDK/ncsu/models/spectre/nom/ami06P.m" "")
)
save( 'i "/N11/D" )
save( 'i /N7/D /N4/D )
run()
selectResult( 'dc )
plot(getData("/N10/D") getData("/N12/D") getData("/N11/D") )
modelFile(
    '("/project/linuxlab/cadence/CDK/ncsu/models/spectre/nom/ami06N.m" "")
    '("/project/linuxlab/cadence/CDK/ncsu/models/spectre/nom/ami06P.m" "")
)
save( 'i /N12/D )
run()
selectResult( 'dc )
plot(getData("/N10/D") getData("/N11/D") )
modelFile(
    '("/project/linuxlab/cadence/CDK/ncsu/models/spectre/nom/ami06N.m" "")
    '("/project/linuxlab/cadence/CDK/ncsu/models/spectre/nom/ami06P.m" "")
)
save( 'i "/N13/D" )
save( 'i /N11/D )
run()
selectResult( 'dc )
plot(getData("/N10/D") getData("/N13/D") )
modelFile(
    '("/project/linuxlab/cadence/CDK/ncsu/models/spectre/nom/ami06N.m" "")
    '("/project/linuxlab/cadence/CDK/ncsu/models/spectre/nom/ami06P.m" "")
)
save( 'i "/N15/D" "/N16/D" )
run()
selectResult( 'dc )
plot(getData("/N10/D") getData("/N13/D") getData("/N15/D") getData("/N16/D") )
modelFile(
    '("/project/linuxlab/cadence/CDK/ncsu/models/spectre/nom/ami06N.m" "")
    '("/project/linuxlab/cadence/CDK/ncsu/models/spectre/nom/ami06P.m" "")
)
run()
selectResult( 'dc )
plot(getData("/N13/D") getData("/N15/D") )
modelFile(
    '("/project/linuxlab/cadence/CDK/ncsu/models/spectre/nom/ami06N.m" "")
    '("/project/linuxlab/cadence/CDK/ncsu/models/spectre/nom/ami06P.m" "")
)
save( 'i "/N16/G" )
run()
selectResult( 'dc )
plot(getData("/N16/G") )
modelFile(
    '("/project/linuxlab/cadence/CDK/ncsu/models/spectre/nom/ami06N.m" "")
    '("/project/linuxlab/cadence/CDK/ncsu/models/spectre/nom/ami06P.m" "")
)
save( 'i "/P13/D" )
save( 'i /N10/D /N13/D /N15/D /N16/G )
run()
selectResult( 'dc )
plot(getData("/P13/D") getData("/N16/D") )
modelFile(
    '("/project/linuxlab/cadence/CDK/ncsu/models/spectre/nom/ami06N.m" "")
    '("/project/linuxlab/cadence/CDK/ncsu/models/spectre/nom/ami06P.m" "")
)
save( 'i "/N17/D" )
run()
selectResult( 'dc )
plot(getData("/N17/D") )
modelFile(
    '("/project/linuxlab/cadence/CDK/ncsu/models/spectre/nom/ami06N.m" "")
    '("/project/linuxlab/cadence/CDK/ncsu/models/spectre/nom/ami06P.m" "")
)
save( 'i "/P18/D" )
save( 'i /P13/D /N16/D /N17/D )
run()
selectResult( 'dc )
plot(getData("/P18/D") )
modelFile(
    '("/project/linuxlab/cadence/CDK/ncsu/models/spectre/nom/ami06N.m" "")
    '("/project/linuxlab/cadence/CDK/ncsu/models/spectre/nom/ami06P.m" "")
)
save( 'i "/N16/D" "/P13/D" )
save( 'i /P18/D )
run()
selectResult( 'dc )
plot(getData("/N16/D") getData("/P13/D") )
modelFile(
    '("/project/linuxlab/cadence/CDK/ncsu/models/spectre/nom/ami06N.m" "")
    '("/project/linuxlab/cadence/CDK/ncsu/models/spectre/nom/ami06P.m" "")
)
save( 'i "/N10/D" "/N11/D" )
run()
selectResult( 'dc )
plot(getData("/N10/D") getData("/N11/D") )
modelFile(
    '("/project/linuxlab/cadence/CDK/ncsu/models/spectre/nom/ami06N.m" "")
    '("/project/linuxlab/cadence/CDK/ncsu/models/spectre/nom/ami06P.m" "")
)
save( 'i "/I40/MINUS" )
save( 'i /N16/D /P13/D /N10/D /N11/D )
run()
selectResult( 'dc )
plot(getData("/I40/MINUS") )
modelFile(
    '("/project/linuxlab/cadence/CDK/ncsu/models/spectre/nom/ami06N.m" "")
    '("/project/linuxlab/cadence/CDK/ncsu/models/spectre/nom/ami06P.m" "")
)
save( 'i "/P13/S" "/N16/D" )
save( 'i /I40/MINUS )
run()
selectResult( 'dc )
plot(getData("/P13/S") getData("/N16/D") )
modelFile(
    '("/project/linuxlab/cadence/CDK/ncsu/models/spectre/nom/ami06N.m" "")
    '("/project/linuxlab/cadence/CDK/ncsu/models/spectre/nom/ami06P.m" "")
)
save( 'i "/N10/D" "/N13/D" "/P13/D" )
save( 'i /P13/S /N16/D )
run()
selectResult( 'dc )
plot(getData("/N10/D") getData("/N13/D") getData("/P13/D") )
modelFile(
    '("/project/linuxlab/cadence/CDK/ncsu/models/spectre/nom/ami06N.m" "")
    '("/project/linuxlab/cadence/CDK/ncsu/models/spectre/nom/ami06P.m" "")
)
save( 'i "/I41/PLUS" "/N16/D" )
save( 'i /N10/D /N13/D )
run()
selectResult( 'dc )
plot(getData("/I41/PLUS") getData("/N16/D") getData("/P13/D") )
modelFile(
    '("/project/linuxlab/cadence/CDK/ncsu/models/spectre/nom/ami06N.m" "")
    '("/project/linuxlab/cadence/CDK/ncsu/models/spectre/nom/ami06P.m" "")
)
save( 'i /I41/PLUS )
run()
selectResult( 'dc )
plot(getData("/P13/D") getData("/N16/D") )
modelFile(
    '("/project/linuxlab/cadence/CDK/ncsu/models/spectre/nom/ami06N.m" "")
    '("/project/linuxlab/cadence/CDK/ncsu/models/spectre/nom/ami06P.m" "")
)
save( 'i "/N13/D" "/P12/D" )
save( 'i /P13/D /N16/D )
run()
selectResult( 'dc )
plot(getData("/N13/D") getData("/P12/D") )
modelFile(
    '("/project/linuxlab/cadence/CDK/ncsu/models/spectre/nom/ami06N.m" "")
    '("/project/linuxlab/cadence/CDK/ncsu/models/spectre/nom/ami06P.m" "")
)
save( 'i "/N10/D" "/N11/D" )
run()
selectResult( 'dc )
plot(getData("/N10/D") getData("/N11/D") )
modelFile(
    '("/project/linuxlab/cadence/CDK/ncsu/models/spectre/nom/ami06N.m" "")
    '("/project/linuxlab/cadence/CDK/ncsu/models/spectre/nom/ami06P.m" "")
)
save( 'i "/R0/PLUS" )
run()
selectResult( 'dc )
plot(getData("/N10/D") getData("/N11/D") getData("/R0/PLUS") )
modelFile(
    '("/project/linuxlab/cadence/CDK/ncsu/models/spectre/nom/ami06N.m" "")
    '("/project/linuxlab/cadence/CDK/ncsu/models/spectre/nom/ami06P.m" "")
)
save( 'i "/N23/D" "/P24/S" )
save( 'i /N13/D /P12/D /N10/D /N11/D /R0/PLUS )
run()
selectResult( 'dc )
plot(getData("/N23/D") getData("/P24/S") )
modelFile(
    '("/project/linuxlab/cadence/CDK/ncsu/models/spectre/nom/ami06N.m" "")
    '("/project/linuxlab/cadence/CDK/ncsu/models/spectre/nom/ami06P.m" "")
)
save( 'i "/N11/D" "/N22/D" "/P23/D" )
run()
selectResult( 'dc )
plot(getData("/N11/D") getData("/N22/D") getData("/P23/D") )
