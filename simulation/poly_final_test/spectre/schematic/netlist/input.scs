// Design: cse562/poly_final_test
simulator lang=spectre
global 0 vdd!
parameters pW=2.4u pL=2u nW=2.4u nL=2u
include "/project/linuxlab/cadence/CDK/ncsu/models/spectre/nom/ami06N.m"
include "/project/linuxlab/cadence/CDK/ncsu/models/spectre/nom/ami06P.m"

// cse562/squarer/schematic
subckt squarer I_In I_Out I_o Squared
    M4 (0 I_Out I_o vdd!) ami06P w=pW l=pL m=1 region=sat
    M1 (0 I_Out I_In vdd!) ami06P w=pW l=pL m=1 region=sat
    M3 (Squared I_o vdd! vdd!) ami06P w=pW l=pL m=1 region=sat
    M2 (I_Out I_In vdd! vdd!) ami06P w=pW l=pL m=1 region=sat
ends squarer

// cse562/poly_final_test/schematic
N11 (net20 net20 net46 net46) ami06N w=nW l=nL m=1 region=sat
N2 (net31 net1 0 0) ami06N w=nW l=nL m=1 region=sat
N3 (net39 net1 0 0) ami06N w=nW l=nL m=1 region=sat
N1 (net10 net1 0 0) ami06N w=nW l=nL m=1 region=sat
N0 (net1 net1 0 0) ami06N w=nW l=nL m=1 region=sat
N5 (net11 net11 0 0) ami06N w=nW l=nL m=1 region=sat
N6 (net13 net11 0 0) ami06N w=nW l=nL m=1 region=sat
N7 (net37 net37 net16 net16) ami06N w=nW l=nL m=1 region=sat
N4 (net29 net29 net16 net16) ami06N w=nW l=nL m=1 region=sat
N10 (net16 net16 0 0) ami06N w=nW l=nL m=1 region=sat
P10 (net13 net13 vdd! vdd!) ami06P w=pW l=pL m=1 region=sat
P11 (net35 net13 vdd! vdd!) ami06P w=pW l=pL m=1 region=sat
P20 (net20 net13 vdd! vdd!) ami06P w=pW l=2*pL m=1 region=sat
P14 (net20 net13 vdd! vdd!) ami06P w=pW l=2*pL m=1 region=sat
P19 (net20 net13 vdd! vdd!) ami06P w=pW l=2*pL m=1 region=sat
P1 (net54 net10 vdd! vdd!) ami06P w=pW l=pL m=1 region=sat
P15 (net29 net10 vdd! vdd!) ami06P w=pW l=2*pL m=1 region=sat
P0 (net10 net10 vdd! vdd!) ami06P w=pW l=pL m=1 region=sat
P5 (net34 net6 vdd! vdd!) ami06P w=pW l=pL m=1 region=sat
P3 (net6 net6 vdd! vdd!) ami06P w=pW l=pL m=1 region=sat
P2 (net27 net6 vdd! vdd!) ami06P w=pW l=pL m=1 region=sat
Input (0 net1) isource type=dc m=1
Bias (net6 0) isource type=dc dc=60n m=1
I13 (net54 net31 net27 net11) squarer
I8 (net35 net39 net34 net37) squarer
V0 (vdd! 0) vsource type=dc dc=3
simulatorOptions options temp=27
dcOp dc
dc dc dev=Input param=dc start=0 stop=60n
save N3:d N11:d
