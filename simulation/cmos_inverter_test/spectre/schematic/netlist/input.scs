// Design: cse563/cmos_inverter_test
simulator lang=spectre
global 0 vdd!
parameters nW=900n nL=900n pW=900n pL=900n
include "/project/linuxlab/cadence/CDK/ncsu/models/spectre/nom/ami06N.m"
include "/project/linuxlab/cadence/CDK/ncsu/models/spectre/nom/ami06P.m"

// cse563/cmos_inverter/schematic
subckt cmos_inverter Vin Vout
    N0 (Vout Vin 0 0) ami06N w=nW l=nL m=1 region=sat
    P0 (Vout Vin vdd! vdd!) ami06P w=pW l=pL m=1 region=sat
ends cmos_inverter

// cse563/cmos_inverter_test/schematic
I0 (net4 net3) cmos_inverter
V1 (net4 0) vsource type=dc
V0 (vdd! 0) vsource type=dc dc=5
C0 (net3 0) capacitor c=1p m=1
simulatorOptions options temp=27
dcOp dc
dc dc dev=V1 param=dc start=0 stop=5
