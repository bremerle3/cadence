simulator( 'spectre )
design(	 "/home/warehouse/lbremer/cadence/simulation/cmos_inverter_test/spectre/schematic/netlist/netlist")
resultsDir( "/home/warehouse/lbremer/cadence/simulation/cmos_inverter_test/spectre/schematic" )
modelFile(
    '("/project/linuxlab/cadence/CDK/ncsu/models/spectre/nom/ami06N.m" "")
    '("/project/linuxlab/cadence/CDK/ncsu/models/spectre/nom/ami06P.m" "")
)
temp( 27 )
run()
modelFile(
    '("/project/linuxlab/cadence/CDK/ncsu/models/spectre/nom/ami06N.m" "")
    '("/project/linuxlab/cadence/CDK/ncsu/models/spectre/nom/ami06P.m" "")
)
desVar(	  "pL" 900n	)
desVar(	  "pW" 900n	)
desVar(	  "nL" 900n	)
desVar(	  "nW" 900n	)
run()
modelFile(
    '("/project/linuxlab/cadence/CDK/ncsu/models/spectre/nom/ami06N.m" "")
    '("/project/linuxlab/cadence/CDK/ncsu/models/spectre/nom/ami06P.m" "")
)
analysis('dc ?saveOppoint t  ?dev "/V1"  ?param "dc"
		?start "0"  ?stop "5"  )
envOption(
	'analysisOrder  list("dc")
)
run()
selectResult( 'dc )
plot(getData("/net3") getData("/net4") )
modelFile(
    '("/project/linuxlab/cadence/CDK/ncsu/models/spectre/nom/ami06N.m" "")
    '("/project/linuxlab/cadence/CDK/ncsu/models/spectre/nom/ami06P.m" "")
)
run()
modelFile(
    '("/project/linuxlab/cadence/CDK/ncsu/models/spectre/nom/ami06N.m" "")
    '("/project/linuxlab/cadence/CDK/ncsu/models/spectre/nom/ami06P.m" "")
)
run()
modelFile(
    '("/project/linuxlab/cadence/CDK/ncsu/models/spectre/nom/ami06N.m" "")
    '("/project/linuxlab/cadence/CDK/ncsu/models/spectre/nom/ami06P.m" "")
)
analysis('dc ?saveOppoint t  ?dev "/V1"  ?param "dc"
		?start "0"  ?stop "5"  )
run()
selectResult( 'dc )
plot(getData("/net4") getData("/net3") )
modelFile(
    '("/project/linuxlab/cadence/CDK/ncsu/models/spectre/nom/ami06N.m" "")
    '("/project/linuxlab/cadence/CDK/ncsu/models/spectre/nom/ami06P.m" "")
)
desVar(	  "pW" 1.5u	)
run()
selectResult( 'dc )
plot(getData("/net4") getData("/net3") )
modelFile(
    '("/project/linuxlab/cadence/CDK/ncsu/models/spectre/nom/ami06N.m" "")
    '("/project/linuxlab/cadence/CDK/ncsu/models/spectre/nom/ami06P.m" "")
)
desVar(	  "pW" 2u	)
run()
selectResult( 'dc )
plot(getData("/net4") getData("/net3") )
modelFile(
    '("/project/linuxlab/cadence/CDK/ncsu/models/spectre/nom/ami06N.m" "")
    '("/project/linuxlab/cadence/CDK/ncsu/models/spectre/nom/ami06P.m" "")
)
run()
selectResult( 'dc )
plot(getData("/net4") getData("/net3") )
modelFile(
    '("/project/linuxlab/cadence/CDK/ncsu/models/spectre/nom/ami06N.m" "")
    '("/project/linuxlab/cadence/CDK/ncsu/models/spectre/nom/ami06P.m" "")
)
desVar(	  "pW" 4u	)
run()
selectResult( 'dc )
plot(getData("/net4") getData("/net3") )
modelFile(
    '("/project/linuxlab/cadence/CDK/ncsu/models/spectre/nom/ami06N.m" "")
    '("/project/linuxlab/cadence/CDK/ncsu/models/spectre/nom/ami06P.m" "")
)
desVar(	  "pW" 3.5u	)
run()
selectResult( 'dc )
plot(getData("/net4") getData("/net3") )
modelFile(
    '("/project/linuxlab/cadence/CDK/ncsu/models/spectre/nom/ami06N.m" "")
    '("/project/linuxlab/cadence/CDK/ncsu/models/spectre/nom/ami06P.m" "")
)
desVar(	  "pW" 3.4u	)
run()
selectResult( 'dc )
plot(getData("/net4") getData("/net3") )
modelFile(
    '("/project/linuxlab/cadence/CDK/ncsu/models/spectre/nom/ami06N.m" "")
    '("/project/linuxlab/cadence/CDK/ncsu/models/spectre/nom/ami06P.m" "")
)
desVar(	  "pW" 3.3u	)
run()
selectResult( 'dc )
plot(getData("/net4") getData("/net3") )
modelFile(
    '("/project/linuxlab/cadence/CDK/ncsu/models/spectre/nom/ami06N.m" "")
    '("/project/linuxlab/cadence/CDK/ncsu/models/spectre/nom/ami06P.m" "")
)
run()
selectResult( 'dc )
plot(getData("/net4") getData("/net3") )
modelFile(
    '("/project/linuxlab/cadence/CDK/ncsu/models/spectre/nom/ami06N.m" "")
    '("/project/linuxlab/cadence/CDK/ncsu/models/spectre/nom/ami06P.m" "")
)
desVar(	  "pW" 3u	)
run()
selectResult( 'dc )
plot(getData("/net4") getData("/net3") )
modelFile(
    '("/project/linuxlab/cadence/CDK/ncsu/models/spectre/nom/ami06N.m" "")
    '("/project/linuxlab/cadence/CDK/ncsu/models/spectre/nom/ami06P.m" "")
)
desVar(	  "pW" 2.8u	)
run()
selectResult( 'dc )
plot(getData("/net4") getData("/net3") )
modelFile(
    '("/project/linuxlab/cadence/CDK/ncsu/models/spectre/nom/ami06N.m" "")
    '("/project/linuxlab/cadence/CDK/ncsu/models/spectre/nom/ami06P.m" "")
)
desVar(	  "pW" 2.9u	)
run()
selectResult( 'dc )
plot(getData("/net4") getData("/net3") )
modelFile(
    '("/project/linuxlab/cadence/CDK/ncsu/models/spectre/nom/ami06N.m" "")
    '("/project/linuxlab/cadence/CDK/ncsu/models/spectre/nom/ami06P.m" "")
)
desVar(	  "pW" 3u	)
run()
selectResult( 'dc )
plot(getData("/net4") getData("/net3") )
modelFile(
    '("/project/linuxlab/cadence/CDK/ncsu/models/spectre/nom/ami06N.m" "")
    '("/project/linuxlab/cadence/CDK/ncsu/models/spectre/nom/ami06P.m" "")
)
desVar(	  "pW" 3.1u	)
run()
selectResult( 'dc )
plot(getData("/net4") getData("/net3") )
