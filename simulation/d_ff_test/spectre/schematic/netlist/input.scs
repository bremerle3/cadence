// Design: cse562/d_ff_test
simulator lang=spectre
global 0 vdd!
parameters nW=900n nL=600n pW=900n pL=600n
include "/project/linuxlab/cadence/CDK/ncsu/models/spectre/nom/ami06N.m"
include "/project/linuxlab/cadence/CDK/ncsu/models/spectre/nom/ami06P.m"

// cse562/simple_latch/schematic
subckt simple_latch CLK D Q
    N13 (Q net22 0 0) ami06N w=nW l=nL m=1 region=sat
    N12 (Q net5 net18 net18) ami06N w=nW l=nL m=1 region=sat
    N11 (net22 net18 0 0) ami06N w=nW l=nL m=1 region=sat
    N10 (net15 CLK net18 net18) ami06N w=nW l=nL m=1 region=sat
    N9 (net15 net12 0 0) ami06N w=nW l=nL m=1 region=sat
    N8 (net15 CLK net8 net8) ami06N w=nW l=nL m=1 region=sat
    N6 (net12 net8 0 0) ami06N w=nW l=nL m=1 region=sat
    N5 (net5 CLK 0 0) ami06N w=nW l=nL m=1 region=sat
    N3 (D net5 net8 net8) ami06N w=nW l=nL m=1 region=sat
    P13 (Q net22 vdd! vdd!) ami06P w=pW l=pL m=1 region=sat
    P12 (net18 net5 Q Q) ami06P w=pW l=pL m=1 region=sat
    P11 (net22 net18 vdd! vdd!) ami06P w=pW l=pL m=1 region=sat
    P10 (net18 net5 net15 net15) ami06P w=pW l=pL m=1 region=sat
    P9 (net15 net12 vdd! vdd!) ami06P w=pW l=pL m=1 region=sat
    P7 (net8 net5 net15 net15) ami06P w=pW l=pL m=1 region=sat
    P6 (net12 net8 vdd! vdd!) ami06P w=pW l=pL m=1 region=sat
    P5 (net5 CLK vdd! vdd!) ami06P w=pW l=pL m=1 region=sat
    P4 (net8 CLK D D) ami06P w=pW l=pL m=1 region=sat
ends simple_latch

// cse562/d_ff_test/schematic
I0 (net2 net3 net4) simple_latch
V0 (vdd! 0) vsource type=dc dc=3
V2 (net3 0) vsource type=pulse val0=0 val1=3 period=24u width=12u
V1 (net2 0) vsource type=pulse val0=0 val1=3 period=4u width=2u
simulatorOptions options temp=27
tran tran stop=160u
