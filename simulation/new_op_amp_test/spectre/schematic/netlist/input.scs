// Design: cse562/new_op_amp_test
simulator lang=spectre
global 0 vdd!
parameters nW=900n nL=600n pW=900n pL=600n
include "/project/linuxlab/cadence/CDK/ncsu/models/spectre/nom/ami06N.m"
include "/project/linuxlab/cadence/CDK/ncsu/models/spectre/nom/ami06P.m"

// cse562/new_op_amp/schematic
subckt new_op_amp Vin\+ Vin\- Vout
    N2 (Vout net14 0 0) ami06N w=nW l=nL m=1 region=sat
    N1 (net14 net10 0 0) ami06N w=nW l=nL m=1 region=sat
    N0 (net10 net10 0 0) ami06N w=nW l=nL m=1 region=sat
    P4 (Vout net7 vdd! vdd!) ami06P w=pW l=pL m=1 region=sat
    P3 (net14 Vin\+ net12 net12) ami06P w=pW l=pL m=1 region=sat
    P2 (net10 Vin\- net12 net12) ami06P w=pW l=pL m=1 region=sat
    P1 (net12 net7 vdd! vdd!) ami06P w=pW l=pL m=1 region=sat
    P0 (net7 net7 vdd! vdd!) ami06P w=pW l=pL m=1 region=sat
    C0 (net14 Vout) capacitor c=100.0f m=1
    I2 (net7 0) isource type=dc dc=200n m=1
ends new_op_amp

// cse562/new_op_amp_test/schematic
I0 (net2 net1 net1) new_op_amp
V0 (net2 0) vsource type=pulse val0=1.45 val1=1.55 period=4u width=2u
V1 (vdd! 0) vsource type=dc dc=3
simulatorOptions options temp=27
tran tran stop=4u
