// Design: cse562/integrator
simulator lang=spectre
global 0 vdd!
parameters pW=900n pL=600n nW=900n nL=600n
include "/project/linuxlab/cadence/CDK/ncsu/models/spectre/nom/ami06N.m"
include "/project/linuxlab/cadence/CDK/ncsu/models/spectre/nom/ami06P.m"

// cse562/proj1_opamp/schematic
subckt proj1_opamp Vin\+ Vin\- Vout
    P4 (net9 Vin\+ net12 vdd!) ami06P w=100.05u l=3u m=1 region=sat
    P3 (net8 Vin\- net9 vdd!) ami06P w=100.05u l=3u m=1 region=sat
    P2 (net9 net7 vdd! vdd!) ami06P w=100.05u l=3u m=1 region=sat
    P1 (Vout net7 vdd! vdd!) ami06P w=100.05u l=3u m=1 region=sat
    P0 (vdd! net7 net14 vdd!) ami06P w=100.05u l=3u m=1 region=sat
    N2 (Vout net12 0 0) ami06N w=100.05u l=3u m=1 region=sat
    N1 (net12 net8 0 0) ami06N w=100.05u l=3u m=1 region=sat
    N0 (0 net8 net8 0) ami06N w=100.05u l=3u m=1 region=sat
    I17 (net14 0) isource type=dc dc=200n m=1
    C0 (Vout net12) capacitor c=10p m=1
ends proj1_opamp

// cse562/integrator/schematic
I0 (0 net02 net016) proj1_opamp
C2 (net016 0) capacitor c=1p m=1
C0 (net023 net016) capacitor c=1n m=1
V3 (net08 0) vsource type=pulse val0=0 val1=3 period=4u delay=300n rise=2p fall=2p width=200n
V1 (vdd! 0) vsource type=dc dc=3
P10 (net024 net024 vdd! vdd!) ami06P w=pW l=pL m=1 region=sat
P4 (net015 net024 vdd! vdd!) ami06P w=pW l=pL m=1 region=sat
P3 (net01 net01 net024 net024) ami06P w=pW l=pL m=1 region=sat
P2 (net02 net01 net015 net015) ami06P w=pW l=pL m=1 region=sat
P1 (net06 net08 vdd! vdd!) ami06P w=pW l=pL m=1 region=sat
P0 (net016 net06 net023 net023) ami06P w=pW l=pL m=1 region=sat
N0 (net06 net08 0 0) ami06N w=nW l=nL m=1 region=sat
N4 (net023 net08 net016 net016) ami06N w=nW l=nL m=1 region=sat
I12 (net01 0) isource type=pwl m=1 wave=[ 300n 0 4u 100n ]
simulatorOptions options temp=27
tran tran stop=4u
save
