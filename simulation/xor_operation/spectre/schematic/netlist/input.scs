// Design: cse463_project/xor_operation
simulator lang=spectre
global 0 vdd!
include "/project/linuxlab/cadence/CDK/ncsu/models/spectre/nom/ami06N.m"
include "/project/linuxlab/cadence/CDK/ncsu/models/spectre/nom/ami06P.m"

// cse463_project/xor_operation/schematic
P1 (A1B A1 vdd! vdd!) ami06P w=900n l=600n m=1 region=sat
P0 (A0B A0 vdd! vdd!) ami06P w=900n l=600n m=1 region=sat
N1 (A1B A1 0 0) ami06N w=900n l=600n m=1 region=sat
N0 (A0B A0 0 0) ami06N w=900n l=600n m=1 region=sat
M3 (Out A0B net11 vdd!) ami06P w=900n l=600n m=1 region=sat
M2 (net11 A1 vdd! vdd!) ami06P w=900n l=600n m=1 region=sat
M1 (Out A0 net12 vdd!) ami06P w=900n l=600n m=1 region=sat
M0 (net12 A1B vdd! vdd!) ami06P w=900n l=600n m=1 region=sat
M7 (net9 A1B 0 gnd!) ami06N w=900n l=600n m=1 region=sat
M6 (Out A0B net9 gnd!) ami06N w=900n l=600n m=1 region=sat
M5 (net10 A1 0 gnd!) ami06N w=900n l=600n m=1 region=sat
M4 (Out A0 net10 gnd!) ami06N w=900n l=600n m=1 region=sat
V0 (vdd! 0) vsource type=dc dc=5
V2 (A1 0) vsource type=pulse val0=5 val1=5 period=200n width=200n
V1 (A0 0) vsource type=pulse val0=0 val1=5 period=200n width=100n
simulatorOptions options temp=27
tran tran stop=2u
