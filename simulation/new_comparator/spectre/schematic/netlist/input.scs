// Design: cse562/new_comparator
simulator lang=spectre
global 0 vdd!
parameters nW=900n nL=600n pW=900n pL=600n
include "/project/linuxlab/cadence/CDK/ncsu/models/spectre/nom/ami06N.m"
include "/project/linuxlab/cadence/CDK/ncsu/models/spectre/nom/ami06P.m"

// cse562/new_comparator/schematic
V5 (net050 0) vsource type=pulse val0=0 val1=3 period=8u rise=2p fall=2p width=4u
V3 (vdd! 0) vsource type=pulse val0=0 val1=3 period=2u rise=2p fall=2p width=1u
N20 (net07 vdd! 0 0) ami06N w=nW l=nL m=1 region=sat
N19 (net011 vdd! net05 net05) ami06N w=nW l=nL m=1 region=sat
N18 (net058 net031 net07 net07) ami06N w=nW l=nL m=1 region=sat
N17 (net011 net05 net058 net058) ami06N w=nW l=nL m=1 region=sat
N16 (net059 net050 net07 net07) ami06N w=nW l=nL m=1 region=sat
N11 (net05 net011 net059 net059) ami06N w=nW l=nL m=1 region=sat
V4 (net031 0) vsource type=dc dc=1.5
P9 (net011 vdd! vdd! vdd!) ami06P w=pW l=pL m=1 region=sat
P8 (net011 net05 vdd! vdd!) ami06P w=pW l=pL m=1 region=sat
P7 (net05 net011 vdd! vdd!) ami06P w=pW l=pL m=1 region=sat
P6 (net05 vdd! vdd! vdd!) ami06P w=pW l=pL m=1 region=sat
simulatorOptions options temp=27
tran tran stop=16u
