// Design: cse562/mirror5
simulator lang=spectre
global 0 vdd!
parameters pW=4u pL=4u
include "/project/linuxlab/cadence/CDK/ncsu/models/spectre/nom/ami06N.m"
include "/project/linuxlab/cadence/CDK/ncsu/models/spectre/nom/ami06P.m"

// cse562/mirror5/schematic
P3 (net010 net010 vdd! vdd!) ami06P w=pW l=pL m=1 region=sat
P1 (net02 net1 vdd! vdd!) ami06P w=pW l=pL m=1 region=sat
P0 (net1 net1 vdd! vdd!) ami06P w=pW l=pL m=1 region=sat
N4 (net010 net04 0 0) ami06N w=pW l=pL m=1 region=sat
N2 (vdd! net02 net04 0) ami06N w=pW l=pL m=1 region=sat
N1 (net07 net07 0 0) ami06N w=pW l=pL m=1 region=sat
N0 (net02 net02 net07 0) ami06N w=pW l=pL m=1 region=sat
V0 (vdd! 0) vsource type=dc dc=3
I6 (net04 0) isource type=dc dc=1n m=1
I0 (net1 0) isource type=dc dc=50n m=1
simulatorOptions options temp=27
dcOp dc
dc dc dev=I0 param=dc start=0 stop=100n
save P1:d I0:sink N0:s N2:s N4:s
