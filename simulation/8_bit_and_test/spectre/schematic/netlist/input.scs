// Design: cse463_project/8_bit_and_test
simulator lang=spectre
global 0 vdd!
include "/project/linuxlab/cadence/CDK/ncsu/models/spectre/nom/ami06N.m"
include "/project/linuxlab/cadence/CDK/ncsu/models/spectre/nom/ami06P.m"

// cse463_project/min_and/schematic
subckt min_and A B Out inh_inh_bn
    M5 (Out net8 vdd! vdd!) ami06P w=900n l=600n m=1 region=sat
    M1 (net8 B vdd! vdd!) ami06P w=900n l=600n m=1 region=sat
    M0 (net8 A vdd! vdd!) ami06P w=900n l=600n m=1 region=sat
    M3 (Out net8 0 gnd!) ami06N w=900n l=600n m=1 region=sat
    M2 (net8 B net15 gnd!) ami06N w=900n l=600n m=1 region=sat
    M4 (net15 A 0 gnd!) ami06N w=900n l=600n m=1 region=sat
ends min_and

// cse463_project/8_bit_and/schematic
subckt cse463_project_8_bit_and_schematic AC0 AC1 AC2 AC3 AC4 AC5 AC6 AC7 IN0 IN4 IN5 IN6 In1 In2 In3 In7 OUT0 OUT1 OUT2 OUT3 OUT4 OUT5 OUT6 OUT7 inh_inh_bn
    I15 (AC7 In7 OUT7 inh_inh_bn) min_and
    I14 (AC6 IN6 OUT6 inh_inh_bn) min_and
    I13 (AC5 IN5 OUT5 inh_inh_bn) min_and
    I12 (AC4 IN4 OUT4 inh_inh_bn) min_and
    I11 (AC3 In3 OUT3 inh_inh_bn) min_and
    I10 (AC2 In2 OUT2 inh_inh_bn) min_and
    I9 (AC1 In1 OUT1 inh_inh_bn) min_and
    I8 (AC0 IN0 OUT0 inh_inh_bn) min_and
ends cse463_project_8_bit_and_schematic

// cse463_project/8_bit_and_test/schematic
V7 (MEM 0) vsource type=pulse val0=5 val1=0 period=100n width=50n
V6 (AC 0) vsource type=pulse val0=5 val1=0 period=200n width=100n
V1 (vdd! 0) vsource type=dc dc=5
C15 (Out0 0) capacitor c=100f m=1
C14 (Out1 0) capacitor c=100f m=1
C13 (Out2 0) capacitor c=100f m=1
C12 (Out3 0) capacitor c=100f m=1
C7 (Out4 0) capacitor c=100f m=1
C5 (Out5 0) capacitor c=100f m=1
C3 (Out6 0) capacitor c=100f m=1
C1 (Out7 0) capacitor c=100f m=1
I1 (AC AC AC AC AC AC AC AC MEM MEM MEM MEM MEM MEM MEM MEM Out0 Out1 Out2 Out3 Out4 Out5 Out6 Out7 0) cse463_project_8_bit_and_schematic
simulatorOptions options temp=27
tran tran stop=400n
