simulator( 'spectre )
design(	 "/home/warehouse/lbremer/cadence/simulation/8_bit_and_test/spectre/schematic/netlist/netlist")
resultsDir( "/home/warehouse/lbremer/cadence/simulation/8_bit_and_test/spectre/schematic" )
modelFile(
    '("/project/linuxlab/cadence/CDK/ncsu/models/spectre/nom/ami06N.m" "")
    '("/project/linuxlab/cadence/CDK/ncsu/models/spectre/nom/ami06P.m" "")
)
analysis('tran ?stop "400n"  )
envOption(
	'analysisOrder  list("tran")
)
save( 'v "/Load" )
temp( 27 )
run()
selectResult( 'tran )
plot(getData("/Out0") getData("/MEM") getData("/AC") getData("/Load") )
modelFile(
    '("/project/linuxlab/cadence/CDK/ncsu/models/spectre/nom/ami06N.m" "")
    '("/project/linuxlab/cadence/CDK/ncsu/models/spectre/nom/ami06P.m" "")
)
delete( 'save 'v /Load )
run()
selectResult( 'tran )
plot(getData("/Out0") getData("/MEM") getData("/AC") )
