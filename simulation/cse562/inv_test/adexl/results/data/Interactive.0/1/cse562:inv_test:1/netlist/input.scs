// Design: cse562/inv_test
simulator lang=spectre
global 0 vdd!
include "/project/linuxlab/cadence/CDK/ncsu/models/spectre/nom/ami06N.m"
include "/project/linuxlab/cadence/CDK/ncsu/models/spectre/nom/ami06P.m"

// cse562/inv/schematic
subckt inv IN OUT
    N0 (OUT IN 0 0) ami06N w=900n l=600n m=1 region=sat
    P0 (OUT IN vdd! vdd!) ami06P w=900n l=600n m=1 region=sat
ends inv

// cse562/inv_test/schematic
I0 (net3 out_test) inv
V0 (net3 0) vsource type=pulse val0=0 val1=5 period=1n
V1 (vdd! 0) vsource type=dc
simulatorOptions options temp=27
tran tran stop=20n
