// Design: 563_final/bb_inv_test
simulator lang=spectre
global 0 vdd!
include "/project/linuxlab/cadence/CDK/ncsu/models/spectre/nom/ami06N.m"
include "/project/linuxlab/cadence/CDK/ncsu/models/spectre/nom/ami06P.m"

// 563_final/ff_inv/schematic
subckt ff_inv in in_bar
    N0 (in_bar in 0 0) ami06N w=1.2u l=600n m=1 region=sat
    P0 (in_bar in vdd! vdd!) ami06P w=1.2u l=600n m=1 region=sat
ends ff_inv

// 563_final/bb_inv_test/schematic
I12 (net2 net03) ff_inv
V1 (net2 0) vsource type=dc
V0 (vdd! 0) vsource type=dc dc=5
C0 (net03 0) capacitor c=100f m=1
simulatorOptions options temp=27
dcOp dc
dc dc dev=V1 param=dc start=0 stop=5
