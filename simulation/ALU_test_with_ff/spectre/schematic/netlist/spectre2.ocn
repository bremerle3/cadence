simulator( 'spectre )
design(	 "/home/warehouse/lbremer/cadence/simulation/ALU_test_with_ff/spectre/schematic/netlist/netlist")
resultsDir( "/home/warehouse/lbremer/cadence/simulation/ALU_test_with_ff/spectre/schematic" )
modelFile(
    '("/project/linuxlab/cadence/CDK/ncsu/models/spectre/nom/ami06N.m" "")
    '("/project/linuxlab/cadence/CDK/ncsu/models/spectre/nom/ami06P.m" "")
)
analysis('tran ?stop "600n"  )
envOption(
	'analysisOrder  list("tran")
)
temp( 27 )
run()
selectResult( 'tran )
plot(getData("/F1") getData("/F2") getData("/out4") getData("/out5") getData("/out6") getData("/out7") getData("/out2") getData("/out1") getData("/out0") getData("/out3") )
modelFile(
    '("/project/linuxlab/cadence/CDK/ncsu/models/spectre/nom/ami06N.m" "")
    '("/project/linuxlab/cadence/CDK/ncsu/models/spectre/nom/ami06P.m" "")
)
run()
selectResult( 'tran )
plot(getData("/F1") getData("/F2") getData("/out4") getData("/out5") getData("/out6") getData("/out7") getData("/out2") getData("/out1") getData("/out0") getData("/out3") )
modelFile(
    '("/project/linuxlab/cadence/CDK/ncsu/models/spectre/nom/ami06N.m" "")
    '("/project/linuxlab/cadence/CDK/ncsu/models/spectre/nom/ami06P.m" "")
)
run()
selectResult( 'tran )
plot(getData("/out4") getData("/out5") getData("/out6") getData("/out7") getData("/out2") getData("/out1") getData("/out0") getData("/out3") getData("/F2") getData("/F1") )
modelFile(
    '("/project/linuxlab/cadence/CDK/ncsu/models/spectre/nom/ami06N.m" "")
    '("/project/linuxlab/cadence/CDK/ncsu/models/spectre/nom/ami06P.m" "")
)
run()
selectResult( 'tran )
plot(getData("/AC<0>") getData("/AC<1>") getData("/AC<2>") getData("/AC<3>") getData("/AC<4>") getData("/AC<5>") getData("/AC<6>") getData("/AC<7>") getData("/out4") getData("/out5") getData("/out6") getData("/out7") getData("/out2") getData("/out1") getData("/out0") getData("/out3") getData("/F2") getData("/F1") )
modelFile(
    '("/project/linuxlab/cadence/CDK/ncsu/models/spectre/nom/ami06N.m" "")
    '("/project/linuxlab/cadence/CDK/ncsu/models/spectre/nom/ami06P.m" "")
)
run()
selectResult( 'tran )
plot(getData("/out4") getData("/out5") getData("/out6") getData("/out7") getData("/out2") getData("/out1") getData("/out0") getData("/out3") getData("/F2") getData("/F1") getData("/AC<0>") getData("/AC<1>") getData("/AC<2>") getData("/AC<3>") getData("/AC<4>") getData("/AC<5>") getData("/AC<6>") getData("/AC<7>") )
modelFile(
    '("/project/linuxlab/cadence/CDK/ncsu/models/spectre/nom/ami06N.m" "")
    '("/project/linuxlab/cadence/CDK/ncsu/models/spectre/nom/ami06P.m" "")
)
run()
selectResult( 'tran )
plot(getData("/out4") getData("/out5") getData("/out6") getData("/out7") getData("/out2") getData("/out1") getData("/out0") getData("/out3") getData("/F2") getData("/F1") getData("/AC<0>") getData("/AC<1>") getData("/AC<2>") getData("/AC<3>") getData("/AC<4>") getData("/AC<5>") getData("/AC<6>") getData("/AC<7>") )
modelFile(
    '("/project/linuxlab/cadence/CDK/ncsu/models/spectre/nom/ami06N.m" "")
    '("/project/linuxlab/cadence/CDK/ncsu/models/spectre/nom/ami06P.m" "")
)
run()
selectResult( 'tran )
plot(getData("/out4") getData("/out5") getData("/out6") getData("/out7") getData("/out2") getData("/out1") getData("/out0") getData("/out3") getData("/F2") getData("/F1") getData("/AC<0>") getData("/AC<1>") getData("/AC<2>") getData("/AC<3>") getData("/AC<4>") getData("/AC<5>") getData("/AC<6>") getData("/AC<7>") )
modelFile(
    '("/project/linuxlab/cadence/CDK/ncsu/models/spectre/nom/ami06N.m" "")
    '("/project/linuxlab/cadence/CDK/ncsu/models/spectre/nom/ami06P.m" "")
)
run()
selectResult( 'tran )
plot(getData("/IN<0>") getData("/IN<1>") getData("/IN<2>") getData("/IN<3>") getData("/out2") getData("/out1") getData("/out0") getData("/out3") getData("/F2") getData("/F1") getData("/AC<0>") getData("/AC<1>") getData("/AC<2>") getData("/AC<3>") )
modelFile(
    '("/project/linuxlab/cadence/CDK/ncsu/models/spectre/nom/ami06N.m" "")
    '("/project/linuxlab/cadence/CDK/ncsu/models/spectre/nom/ami06P.m" "")
)
run()
selectResult( 'tran )
plot(getData("/out2") getData("/out1") getData("/out0") getData("/out3") getData("/F2") getData("/F1") getData("/AC<0>") getData("/AC<1>") getData("/AC<2>") getData("/AC<3>") getData("/IN<0>") getData("/IN<1>") getData("/IN<2>") getData("/IN<3>") )
modelFile(
    '("/project/linuxlab/cadence/CDK/ncsu/models/spectre/nom/ami06N.m" "")
    '("/project/linuxlab/cadence/CDK/ncsu/models/spectre/nom/ami06P.m" "")
)
analysis('tran ?stop "1800n"  )
run()
selectResult( 'tran )
plot(getData("/out2") getData("/out1") getData("/out0") getData("/out3") getData("/F2") getData("/F1") getData("/AC<0>") getData("/AC<1>") getData("/AC<2>") getData("/AC<3>") getData("/IN<0>") getData("/IN<1>") getData("/IN<2>") getData("/IN<3>") )
modelFile(
    '("/project/linuxlab/cadence/CDK/ncsu/models/spectre/nom/ami06N.m" "")
    '("/project/linuxlab/cadence/CDK/ncsu/models/spectre/nom/ami06P.m" "")
)
run()
selectResult( 'tran )
plot(getData("/IN<0>") getData("/IN<1>") getData("/IN<2>") getData("/IN<3>") getData("/AC<0>") getData("/AC<1>") getData("/AC<2>") getData("/AC<3>") getData("/OUT<0>") getData("/OUT<1>") getData("/OUT<2>") getData("/OUT<3>") )
modelFile(
    '("/project/linuxlab/cadence/CDK/ncsu/models/spectre/nom/ami06N.m" "")
    '("/project/linuxlab/cadence/CDK/ncsu/models/spectre/nom/ami06P.m" "")
)
run()
selectResult( 'tran )
plot(getData("/OUT<0>") getData("/OUT<1>") getData("/OUT<2>") getData("/OUT<3>") getData("/AC<0>") getData("/AC<1>") getData("/AC<2>") getData("/AC<3>") getData("/IN<0>") getData("/IN<1>") getData("/IN<2>") getData("/IN<3>") )
modelFile(
    '("/project/linuxlab/cadence/CDK/ncsu/models/spectre/nom/ami06N.m" "")
    '("/project/linuxlab/cadence/CDK/ncsu/models/spectre/nom/ami06P.m" "")
)
run()
selectResult( 'tran )
plot(getData("/OUT<0>") getData("/OUT<1>") getData("/OUT<2>") getData("/OUT<3>") getData("/AC<0>") getData("/AC<1>") getData("/AC<2>") getData("/AC<3>") getData("/IN<0>") getData("/IN<1>") getData("/IN<2>") getData("/IN<3>") )
modelFile(
    '("/project/linuxlab/cadence/CDK/ncsu/models/spectre/nom/ami06N.m" "")
    '("/project/linuxlab/cadence/CDK/ncsu/models/spectre/nom/ami06P.m" "")
)
run()
selectResult( 'tran )
plot(getData("/F1") getData("/F2") getData("/OUT<0>") getData("/OUT<1>") getData("/OUT<2>") getData("/OUT<3>") getData("/AC<0>") getData("/AC<1>") getData("/AC<2>") getData("/AC<3>") getData("/IN<0>") getData("/IN<1>") getData("/IN<2>") getData("/IN<3>") )
modelFile(
    '("/project/linuxlab/cadence/CDK/ncsu/models/spectre/nom/ami06N.m" "")
    '("/project/linuxlab/cadence/CDK/ncsu/models/spectre/nom/ami06P.m" "")
)
run()
selectResult( 'tran )
plot(getData("/out3") getData("/out2") getData("/out1") getData("/out0") getData("/F1") getData("/F2") getData("/OUT<0>") getData("/OUT<1>") getData("/OUT<2>") getData("/OUT<3>") getData("/AC<0>") getData("/AC<1>") getData("/AC<2>") getData("/AC<3>") getData("/IN<0>") getData("/IN<1>") getData("/IN<2>") getData("/IN<3>") )
modelFile(
    '("/project/linuxlab/cadence/CDK/ncsu/models/spectre/nom/ami06N.m" "")
    '("/project/linuxlab/cadence/CDK/ncsu/models/spectre/nom/ami06P.m" "")
)
run()
selectResult( 'tran )
plot(getData("/OUT<0>") getData("/OUT<1>") getData("/OUT<2>") getData("/OUT<3>") getData("/AC<0>") getData("/AC<1>") getData("/AC<2>") getData("/AC<3>") getData("/IN<0>") getData("/IN<1>") getData("/IN<2>") getData("/IN<3>") getData("/F2") getData("/F1") getData("/out0") getData("/out1") getData("/out2") getData("/out3") )
