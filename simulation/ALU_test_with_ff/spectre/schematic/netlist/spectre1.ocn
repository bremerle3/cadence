simulator( 'spectre )
design(	 "/home/warehouse/lbremer/cadence/simulation/ALU_test_with_ff/spectre/schematic/netlist/netlist")
resultsDir( "/home/warehouse/lbremer/cadence/simulation/ALU_test_with_ff/spectre/schematic" )
modelFile(
    '("/project/linuxlab/cadence/CDK/ncsu/models/spectre/nom/ami06N.m" "")
    '("/project/linuxlab/cadence/CDK/ncsu/models/spectre/nom/ami06P.m" "")
)
analysis('tran ?stop "600n"  )
envOption(
	'analysisOrder  list("tran")
)
temp( 27 )
run()
selectResult( 'tran )
plot(getData("/F2") getData("/out0") getData("/out1") getData("/out2") getData("/out3") getData("/out4") getData("/out5") getData("/out6") getData("/out7") getData("/IN<0>") getData("/IN<1>") getData("/IN<2>") getData("/IN<3>") getData("/IN<4>") getData("/IN<5>") getData("/IN<6>") getData("/IN<7>") )
modelFile(
    '("/project/linuxlab/cadence/CDK/ncsu/models/spectre/nom/ami06N.m" "")
    '("/project/linuxlab/cadence/CDK/ncsu/models/spectre/nom/ami06P.m" "")
)
run()
selectResult( 'tran )
plot(getData("/F1") getData("/F2") getData("/out0") getData("/out1") getData("/out2") getData("/out3") getData("/out4") getData("/out5") getData("/out6") getData("/out7") )
modelFile(
    '("/project/linuxlab/cadence/CDK/ncsu/models/spectre/nom/ami06N.m" "")
    '("/project/linuxlab/cadence/CDK/ncsu/models/spectre/nom/ami06P.m" "")
)
run()
selectResult( 'tran )
plot(getData("/OUT<0>") getData("/OUT<1>") getData("/OUT<2>") getData("/OUT<3>") getData("/OUT<4>") getData("/OUT<5>") getData("/OUT<6>") getData("/OUT<7>") )
modelFile(
    '("/project/linuxlab/cadence/CDK/ncsu/models/spectre/nom/ami06N.m" "")
    '("/project/linuxlab/cadence/CDK/ncsu/models/spectre/nom/ami06P.m" "")
)
run()
selectResult( 'tran )
plot(getData("/OUT<0>") getData("/OUT<1>") getData("/OUT<2>") getData("/OUT<3>") getData("/OUT<4>") getData("/OUT<5>") getData("/OUT<6>") getData("/OUT<7>") )
modelFile(
    '("/project/linuxlab/cadence/CDK/ncsu/models/spectre/nom/ami06N.m" "")
    '("/project/linuxlab/cadence/CDK/ncsu/models/spectre/nom/ami06P.m" "")
)
run()
selectResult( 'tran )
plot(getData("/OUT<0>") getData("/OUT<1>") getData("/OUT<2>") getData("/OUT<3>") getData("/OUT<4>") getData("/OUT<5>") getData("/OUT<6>") getData("/OUT<7>") )
