simulator( 'spectre )
design(	 "/home/warehouse/lbremer/cadence/simulation/inv_test/spectre/schematic/netlist/netlist")
resultsDir( "/home/warehouse/lbremer/cadence/simulation/inv_test/spectre/schematic" )
modelFile(
    '("/project/linuxlab/cadence/CDK/ncsu/models/spectre/nom/ami06N.m" "")
    '("/project/linuxlab/cadence/CDK/ncsu/models/spectre/nom/ami06P.m" "")
)
analysis('tran ?stop "20n"  )
envOption(
	'analysisOrder  list("tran")
)
temp( 27 )
run()
selectResult( 'tran )
plot(getData("/out_test") getData("/net3") )
modelFile(
    '("/project/linuxlab/cadence/CDK/ncsu/models/spectre/nom/ami06N.m" "")
    '("/project/linuxlab/cadence/CDK/ncsu/models/spectre/nom/ami06P.m" "")
)
analysis('dc ?saveOppoint t  ?dev "/V0"  ?param "dc"
		?start "0"  ?stop "5"  )
envOption(
	'analysisOrder  list("tran" "dc")
)
save( 'i "/I0/IN" "/I0/OUT" )
run()
selectResult( 'tran )
plot(getData("/net3") getData("/out_test") getData("/I0/IN") getData("/I0/OUT") )
selectResult( 'dc )
plot(getData("/net3") getData("/out_test") getData("/I0/IN") getData("/I0/OUT") )
modelFile(
    '("/project/linuxlab/cadence/CDK/ncsu/models/spectre/nom/ami06N.m" "")
    '("/project/linuxlab/cadence/CDK/ncsu/models/spectre/nom/ami06P.m" "")
)
run()
selectResult( 'tran )
plot(getData("/net3") getData("/out_test") )
selectResult( 'dc )
plot(getData("/net3") getData("/out_test") )
modelFile(
    '("/project/linuxlab/cadence/CDK/ncsu/models/spectre/nom/ami06N.m" "")
    '("/project/linuxlab/cadence/CDK/ncsu/models/spectre/nom/ami06P.m" "")
)
run()
selectResult( 'tran )
plot(getData("/I0/IN") getData("/I0/OUT") )
selectResult( 'dc )
plot(getData("/I0/IN") getData("/I0/OUT") )
modelFile(
    '("/project/linuxlab/cadence/CDK/ncsu/models/spectre/nom/ami06N.m" "")
    '("/project/linuxlab/cadence/CDK/ncsu/models/spectre/nom/ami06P.m" "")
)
run()
selectResult( 'tran )
plot(getData("/net3") getData("/out_test") )
selectResult( 'dc )
plot(getData("/net3") getData("/out_test") )
modelFile(
    '("/project/linuxlab/cadence/CDK/ncsu/models/spectre/nom/ami06N.m" "")
    '("/project/linuxlab/cadence/CDK/ncsu/models/spectre/nom/ami06P.m" "")
)
analysis('dc ?dev "/V1"  )
run()
selectResult( 'tran )
plot(getData("/net3") getData("/out_test") )
selectResult( 'dc )
plot(getData("/net3") getData("/out_test") )
