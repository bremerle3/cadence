// Design: 563_final/inv_test
simulator lang=spectre
global 0 vdd!
include "/project/linuxlab/cadence/CDK/ncsu/models/spectre/nom/ami06N.m"
include "/project/linuxlab/cadence/CDK/ncsu/models/spectre/nom/ami06P.m"

// 563_final/inv/schematic
subckt inv_schematic Vin Vout
    N0 (Vout Vin 0 0) ami06N w=900n l=900n m=1 region=sat
    P0 (Vout Vin vdd! vdd!) ami06P w=3.3u l=900n m=1 region=sat
ends inv_schematic

// 563_final/inv_test/schematic
I0 (net1 net2) inv_schematic
V1 (net1 0) vsource type=dc
V0 (vdd! 0) vsource type=dc dc=5
C0 (net2 0) capacitor c=1p m=1
simulatorOptions options temp=27
dcOp dc
dc dc dev=V1 param=dc start=0 stop=5
