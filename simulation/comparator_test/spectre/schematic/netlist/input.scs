// Design: cse562/comparator_test
simulator lang=spectre
global 0 vdd!
parameters nW=900u nL=600u pW=900u pL=600u
include "/project/linuxlab/cadence/CDK/ncsu/models/spectre/nom/ami06N.m"
include "/project/linuxlab/cadence/CDK/ncsu/models/spectre/nom/ami06P.m"

// cse562/comparator/schematic
subckt comparator V\+ V\- Vout
    I27 (vdd! net2) isource type=dc dc=200n m=1
    N2 (Vout net15 0 0) ami06N w=nW l=nL m=1 region=sat
    N1 (net15 V\+ net5 net5) ami06N w=nW l=nL m=1 region=sat
    N17 (net3 V\- net5 net5) ami06N w=nW l=nL m=1 region=sat
    N15 (net5 net2 net9 net9) ami06N w=nW l=nL m=1 region=sat
    N14 (net2 net2 net1 net1) ami06N w=nW l=nL m=1 region=sat
    N13 (net9 net1 0 0) ami06N w=nW l=nL m=1 region=sat
    N12 (net1 net1 0 0) ami06N w=nW l=nL m=1 region=sat
    P4 (net15 net3 vdd! vdd!) ami06P w=pW l=pL m=1 region=sat
    P5 (Vout net15 vdd! vdd!) ami06P w=pW l=pL m=1 region=sat
    P2 (net3 net3 vdd! vdd!) ami06P w=pW l=pL m=1 region=sat
ends comparator

// cse562/comparator_test/schematic
I0 (net1 net2 net3) comparator
V0 (net1 0) vsource type=pulse val0=200m val1=2.8 period=4u rise=2p fall=2p width=2u
V2 (vdd! 0) vsource type=dc dc=3
V1 (net2 0) vsource type=dc dc=1.5
C0 (net3 0) capacitor c=1p m=1
simulatorOptions options temp=27
tran tran stop=4u
