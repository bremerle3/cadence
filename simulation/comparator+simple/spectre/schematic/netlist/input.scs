// Design: cse562/comparator+simple
simulator lang=spectre
global 0 vdd!
parameters pW=900n pL=600n nW=900n nL=600n
include "/project/linuxlab/cadence/CDK/ncsu/models/spectre/nom/ami06N.m"
include "/project/linuxlab/cadence/CDK/ncsu/models/spectre/nom/ami06P.m"

// cse562/comparator+simple/schematic
I27 (vdd! net2) isource type=dc dc=200n m=1
V0 (net17 0) vsource type=pulse val0=200m val1=2.8 period=4u rise=2p fall=2p width=2u
P4 (net6 net3 vdd! vdd!) ami06P w=pW l=pL m=1 region=sat
P2 (net3 net3 vdd! vdd!) ami06P w=pW l=pL m=1 region=sat
P5 (net7 net6 vdd! vdd!) ami06P w=pW l=pL m=1 region=sat
C0 (net7 0) capacitor c=1p m=1
V2 (vdd! 0) vsource type=dc dc=3
V1 (net18 0) vsource type=dc dc=1.5
N1 (net6 net17 net5 net5) ami06N w=nW l=nL m=1 region=sat
N17 (net3 net18 net5 net5) ami06N w=nW l=nL m=1 region=sat
N15 (net5 net2 net10 net10) ami06N w=nW l=nL m=1 region=sat
N14 (net2 net2 net1 net1) ami06N w=nW l=nL m=1 region=sat
N2 (net7 net6 0 0) ami06N w=nW l=nL m=1 region=sat
N13 (net10 net1 0 0) ami06N w=nW l=nL m=1 region=sat
N12 (net1 net1 0 0) ami06N w=nW l=nL m=1 region=sat
simulatorOptions options temp=27
tran tran stop=4u
