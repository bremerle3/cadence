simulator( 'spectre )
design(	 "/home/warehouse/lbremer/cadence/simulation/comparator+simple/spectre/schematic/netlist/netlist")
resultsDir( "/home/warehouse/lbremer/cadence/simulation/comparator+simple/spectre/schematic" )
modelFile(
    '("/project/linuxlab/cadence/CDK/ncsu/models/spectre/nom/ami06N.m" "")
    '("/project/linuxlab/cadence/CDK/ncsu/models/spectre/nom/ami06P.m" "")
)
analysis('dc ?saveOppoint t  ?dev "/V4"  ?param "dc"
		?start "0"  ?stop "3"  )
envOption(
	'analysisOrder  list("dc")
)
temp( 27 )
run()
selectResult( 'dc )
plot(getData("/net022") getData("/net028") )
modelFile(
    '("/project/linuxlab/cadence/CDK/ncsu/models/spectre/nom/ami06N.m" "")
    '("/project/linuxlab/cadence/CDK/ncsu/models/spectre/nom/ami06P.m" "")
)
desVar(	  "pL" 2u	)
desVar(	  "pW" 2u	)
desVar(	  "nL" 2u	)
desVar(	  "nW" 2u	)
run()
selectResult( 'dc )
plot(getData("/net022") getData("/net028") )
modelFile(
    '("/project/linuxlab/cadence/CDK/ncsu/models/spectre/nom/ami06N.m" "")
    '("/project/linuxlab/cadence/CDK/ncsu/models/spectre/nom/ami06P.m" "")
)
desVar(	  "pL" 600u	)
desVar(	  "pW" 900u	)
desVar(	  "nL" 600u	)
desVar(	  "nW" 900u	)
run()
selectResult( 'dc )
plot(getData("/net028") getData("/net022") )
modelFile(
    '("/project/linuxlab/cadence/CDK/ncsu/models/spectre/nom/ami06N.m" "")
    '("/project/linuxlab/cadence/CDK/ncsu/models/spectre/nom/ami06P.m" "")
)
run()
selectResult( 'dc )
plot(getData("/net028") getData("/net022") )
modelFile(
    '("/project/linuxlab/cadence/CDK/ncsu/models/spectre/nom/ami06N.m" "")
    '("/project/linuxlab/cadence/CDK/ncsu/models/spectre/nom/ami06P.m" "")
)
analysis('tran ?stop "4u"  )
envOption(
	'analysisOrder  list("dc" "tran")
)
run()
selectResult( 'tran )
plot(getData("/net028") getData("/net022") )
modelFile(
    '("/project/linuxlab/cadence/CDK/ncsu/models/spectre/nom/ami06N.m" "")
    '("/project/linuxlab/cadence/CDK/ncsu/models/spectre/nom/ami06P.m" "")
)
run()
selectResult( 'tran )
plot(getData("/net028") getData("/net022") )
