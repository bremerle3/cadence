simulator( 'spectre )
design(	 "/home/warehouse/lbremer/cadence/simulation/comparator+simple/spectre/schematic/netlist/netlist")
resultsDir( "/home/warehouse/lbremer/cadence/simulation/comparator+simple/spectre/schematic" )
modelFile(
    '("/project/linuxlab/cadence/CDK/ncsu/models/spectre/nom/ami06N.m" "")
    '("/project/linuxlab/cadence/CDK/ncsu/models/spectre/nom/ami06P.m" "")
)
analysis('tran ?stop "4u"  )
envOption(
	'analysisOrder  list("tran")
)
temp( 27 )
run()
selectResult( 'tran )
plot(getData("/net7") getData("/net17") )
modelFile(
    '("/project/linuxlab/cadence/CDK/ncsu/models/spectre/nom/ami06N.m" "")
    '("/project/linuxlab/cadence/CDK/ncsu/models/spectre/nom/ami06P.m" "")
)
desVar(	  "nL" 600u	)
desVar(	  "nW" 900u	)
desVar(	  "pL" 600u	)
desVar(	  "pW" 900u	)
run()
selectResult( 'tran )
plot(getData("/net7") getData("/net17") )
modelFile(
    '("/project/linuxlab/cadence/CDK/ncsu/models/spectre/nom/ami06N.m" "")
    '("/project/linuxlab/cadence/CDK/ncsu/models/spectre/nom/ami06P.m" "")
)
desVar(	  "nL" 600n	)
desVar(	  "nW" 900n	)
desVar(	  "pL" 600n	)
desVar(	  "pW" 900n	)
run()
selectResult( 'tran )
plot(getData("/net17") getData("/net7") )
