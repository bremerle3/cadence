// Design: cse562/bad_comparator
simulator lang=spectre
global 0 vdd!
parameters nW=900n nL=600n pW=900n pL=600n
include "/project/linuxlab/cadence/CDK/ncsu/models/spectre/nom/ami06N.m"
include "/project/linuxlab/cadence/CDK/ncsu/models/spectre/nom/ami06P.m"

// cse562/bad_comparator/schematic
V3 (net6 0) vsource type=dc dc=1.5
V1 (vdd! 0) vsource type=dc dc=3
V4 (net5 0) vsource type=dc dc=1.5
N0 (net08 net7 0 0) ami06N w=nW l=nL m=1 region=sat
N17 (net7 net5 0 0) ami06N w=nW l=nL m=1 region=sat
P0 (net08 net7 vdd! vdd!) ami06P w=pW l=pL m=1 region=sat
P2 (net7 net6 vdd! vdd!) ami06P w=pW l=pL m=1 region=sat
simulatorOptions options temp=27
dcOp dc
dc dc dev=V3 param=dc start=0 stop=3
