simulator( 'spectre )
design(	 "/home/warehouse/lbremer/cadence/simulation/ALU_test/spectre/schematic/netlist/netlist")
resultsDir( "/home/warehouse/lbremer/cadence/simulation/ALU_test/spectre/schematic" )
modelFile(
    '("/project/linuxlab/cadence/CDK/ncsu/models/spectre/nom/ami06N.m" "")
    '("/project/linuxlab/cadence/CDK/ncsu/models/spectre/nom/ami06P.m" "")
)
temp( 27 )
run()
modelFile(
    '("/project/linuxlab/cadence/CDK/ncsu/models/spectre/nom/ami06N.m" "")
    '("/project/linuxlab/cadence/CDK/ncsu/models/spectre/nom/ami06P.m" "")
)
analysis('tran ?stop "400n"  )
envOption(
	'analysisOrder  list("tran")
)
run()
selectResult( 'tran )
plot(getData("/OUT<0>") getData("/OUT<1>") getData("/OUT<2>") getData("/OUT<3>") getData("/OUT<4>") getData("/OUT<5>") getData("/OUT<6>") getData("/OUT<7>") getData("/IN<0>") getData("/IN<1>") getData("/IN<2>") getData("/IN<3>") getData("/IN<4>") getData("/IN<5>") getData("/IN<6>") getData("/IN<7>") )
