simulator( 'spectre )
design(	 "/home/warehouse/lbremer/cadence/simulation/ALU_test/spectre/schematic/netlist/netlist")
resultsDir( "/home/warehouse/lbremer/cadence/simulation/ALU_test/spectre/schematic" )
modelFile(
    '("/project/linuxlab/cadence/CDK/ncsu/models/spectre/nom/ami06N.m" "")
    '("/project/linuxlab/cadence/CDK/ncsu/models/spectre/nom/ami06P.m" "")
)
analysis('tran ?stop "600n"  )
envOption(
	'analysisOrder  list("tran")
)
temp( 27 )
run()
selectResult( 'tran )
plot(getData("/I2/MUX7<0>") getData("/I2/MUX6<0>") getData("/I2/MUX5<0>") getData("/I2/MUX4<0>") getData("/I2/MUX3<0>") getData("/I2/MUX2<0>") getData("/I2/MUX1<0>") getData("/I2/MUX0<0>") getData("/IN<7>") getData("/IN<6>") getData("/IN<5>") getData("/IN<4>") getData("/IN<3>") getData("/IN<2>") getData("/IN<1>") getData("/IN<0>") )
modelFile(
    '("/project/linuxlab/cadence/CDK/ncsu/models/spectre/nom/ami06N.m" "")
    '("/project/linuxlab/cadence/CDK/ncsu/models/spectre/nom/ami06P.m" "")
)
run()
selectResult( 'tran )
plot(getData("/I2/MUX7<0>") getData("/I2/MUX6<0>") getData("/I2/MUX5<0>") getData("/I2/MUX4<0>") getData("/I2/MUX3<0>") getData("/I2/MUX2<0>") getData("/I2/MUX1<0>") getData("/I2/MUX0<0>") getData("/IN<7>") getData("/IN<6>") getData("/IN<5>") getData("/IN<4>") getData("/IN<3>") getData("/IN<2>") getData("/IN<1>") getData("/IN<0>") )
modelFile(
    '("/project/linuxlab/cadence/CDK/ncsu/models/spectre/nom/ami06N.m" "")
    '("/project/linuxlab/cadence/CDK/ncsu/models/spectre/nom/ami06P.m" "")
)
run()
selectResult( 'tran )
plot(getData("/I2/MUX0<0>") getData("/IN<0>") )
modelFile(
    '("/project/linuxlab/cadence/CDK/ncsu/models/spectre/nom/ami06N.m" "")
    '("/project/linuxlab/cadence/CDK/ncsu/models/spectre/nom/ami06P.m" "")
)
run()
selectResult( 'tran )
plot(getData("/I2/MUX0<0>") getData("/IN<0>") )
modelFile(
    '("/project/linuxlab/cadence/CDK/ncsu/models/spectre/nom/ami06N.m" "")
    '("/project/linuxlab/cadence/CDK/ncsu/models/spectre/nom/ami06P.m" "")
)
run()
selectResult( 'tran )
plot(getData("/I2/MUX0<0>") getData("/IN<0>") )
modelFile(
    '("/project/linuxlab/cadence/CDK/ncsu/models/spectre/nom/ami06N.m" "")
    '("/project/linuxlab/cadence/CDK/ncsu/models/spectre/nom/ami06P.m" "")
)
run()
selectResult( 'tran )
plot(getData("/I2/MUX0<0>") getData("/IN<0>") )
modelFile(
    '("/project/linuxlab/cadence/CDK/ncsu/models/spectre/nom/ami06N.m" "")
    '("/project/linuxlab/cadence/CDK/ncsu/models/spectre/nom/ami06P.m" "")
)
run()
selectResult( 'tran )
plot(getData("/I2/MUX0<0>") getData("/IN<0>") )
modelFile(
    '("/project/linuxlab/cadence/CDK/ncsu/models/spectre/nom/ami06N.m" "")
    '("/project/linuxlab/cadence/CDK/ncsu/models/spectre/nom/ami06P.m" "")
)
run()
selectResult( 'tran )
plot(getData("/I59/MUX0<0>") getData("/IN<0>") )
modelFile(
    '("/project/linuxlab/cadence/CDK/ncsu/models/spectre/nom/ami06N.m" "")
    '("/project/linuxlab/cadence/CDK/ncsu/models/spectre/nom/ami06P.m" "")
)
run()
selectResult( 'tran )
plot(getData("/OUT<0>") getData("/IN<0>") getData("/I59/MUX0<0>") )
modelFile(
    '("/project/linuxlab/cadence/CDK/ncsu/models/spectre/nom/ami06N.m" "")
    '("/project/linuxlab/cadence/CDK/ncsu/models/spectre/nom/ami06P.m" "")
)
run()
selectResult( 'tran )
plot(getData("/S<1>") getData("/S<0>") getData("/S<3>") getData("/S<2>") getData("/S<5>") getData("/S<4>") getData("/IN<0>") getData("/I59/MUX0<0>") getData("/OUT<0>") )
modelFile(
    '("/project/linuxlab/cadence/CDK/ncsu/models/spectre/nom/ami06N.m" "")
    '("/project/linuxlab/cadence/CDK/ncsu/models/spectre/nom/ami06P.m" "")
)
run()
selectResult( 'tran )
plot(getData("/I59/I6/net18") getData("/I59/I6/net017") getData("/IN<0>") )
