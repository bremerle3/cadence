// Design: 563_final/test_543
simulator lang=spectre
global 0 vdd!
include "/project/linuxlab/cadence/CDK/ncsu/models/spectre/nom/ami06N.m"
include "/project/linuxlab/cadence/CDK/ncsu/models/spectre/nom/ami06P.m"

// 563_final/test_543/schematic
M0 (Out In 0 gnd!) ami06N w=1.35u l=600n m=1 region=sat
M1 (Out In vdd! vdd!) ami06P w=1.35u l=600n m=1 region=sat
V0 (In 0) vsource type=pulse val0=0 val1=5 period=100n
V1 (vdd! 0) vsource type=dc dc=5
simulatorOptions options temp=27
tran tran stop=100n
