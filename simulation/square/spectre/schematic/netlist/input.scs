// Design: cse562/square
simulator lang=spectre
global 0 vdd!
include "/project/linuxlab/cadence/CDK/ncsu/models/spectre/nom/ami06N.m"
include "/project/linuxlab/cadence/CDK/ncsu/models/spectre/nom/ami06P.m"

// cse562/square/schematic
N7 (vdd! net3 0 0) ami06N w=900n l=600n m=1 region=sat
N6 (vdd! net1 net3 0) ami06N w=900n l=600n m=1 region=sat
N5 (net2 net2 0 0) ami06N w=900n l=600n m=1 region=sat
N4 (net1 net1 net2 0) ami06N w=900n l=600n m=1 region=sat
I21 (net3 0) isource type=dc dc=2n m=1
I17 (vdd! net1) isource type=dc dc=10n m=1
V2 (vdd! 0) vsource type=dc dc=3
simulatorOptions options temp=27
dcOp dc
dc dc dev=I17 param=dc start=0 stop=5n
