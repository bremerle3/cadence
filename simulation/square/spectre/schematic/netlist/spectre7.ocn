simulator( 'spectre )
design(	 "/home/warehouse/lbremer/cadence/simulation/square/spectre/schematic/netlist/netlist")
resultsDir( "/home/warehouse/lbremer/cadence/simulation/square/spectre/schematic" )
modelFile(
    '("/project/linuxlab/cadence/CDK/ncsu/models/spectre/nom/ami06N.m" "")
    '("/project/linuxlab/cadence/CDK/ncsu/models/spectre/nom/ami06P.m" "")
)
analysis('dc ?saveOppoint t  ?dev "/I0"  ?param "dc"
		?start "0"  ?stop "100n"  )
envOption(
	'analysisOrder  list("dc")
)
save( 'i "/N0/D" "/N1/D" "/N2/D" "/N3/D" )
temp( 27 )
run()
selectResult( 'dc )
plot(getData("/N0/D") getData("/N1/D") getData("/N2/D") getData("/N3/D") )
modelFile(
    '("/project/linuxlab/cadence/CDK/ncsu/models/spectre/nom/ami06N.m" "")
    '("/project/linuxlab/cadence/CDK/ncsu/models/spectre/nom/ami06P.m" "")
)
run()
selectResult( 'dc )
plot(getData("/N0/D") getData("/N1/D") getData("/N2/D") getData("/N3/D") )
modelFile(
    '("/project/linuxlab/cadence/CDK/ncsu/models/spectre/nom/ami06N.m" "")
    '("/project/linuxlab/cadence/CDK/ncsu/models/spectre/nom/ami06P.m" "")
)
run()
selectResult( 'dc )
plot(getData("/N0/D") getData("/N1/D") getData("/N2/D") getData("/N3/D") )
