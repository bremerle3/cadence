// Design: cse562/proj1_opamp_sweeptest
simulator lang=spectre
global 0 vdd!
include "/project/linuxlab/cadence/CDK/ncsu/models/spectre/nom/ami06N.m"
include "/project/linuxlab/cadence/CDK/ncsu/models/spectre/nom/ami06P.m"

// cse562/proj1_opamp/schematic
subckt proj1_opamp Vin\+ Vin\- Vout
    P4 (net9 Vin\+ net12 vdd!) ami06P w=100.05u l=3u m=1 region=sat
    P3 (net8 Vin\- net9 vdd!) ami06P w=100.05u l=3u m=1 region=sat
    P2 (net9 net7 vdd! vdd!) ami06P w=100.05u l=3u m=1 region=sat
    P1 (Vout net7 vdd! vdd!) ami06P w=100.05u l=3u m=1 region=sat
    P0 (vdd! net7 net14 vdd!) ami06P w=100.05u l=3u m=1 region=sat
    N2 (Vout net12 0 0) ami06N w=100.05u l=3u m=1 region=sat
    N1 (net12 net8 0 0) ami06N w=100.05u l=3u m=1 region=sat
    N0 (0 net8 net8 0) ami06N w=100.05u l=3u m=1 region=sat
    I17 (net14 0) isource type=dc dc=10nA m=1
    C0 (Vout net12) capacitor c=0 m=1
ends proj1_opamp

// cse562/proj1_opamp_sweeptest/schematic
I0 (net1 net3 net1) proj1_opamp
V0 (vdd! 0) vsource type=dc dc=3
V1 (net3 0) vsource type=sine
simulatorOptions options temp=27
pz ( net1 ) pz iprobe=V1 param=freq values=[0 0.1 100]
