ADE simulation setup
Run mode: Single Run, Sweeps and Corners
Tests:
  cse562:inv_test:1: cse562/inv_test/schematic, simulator spectre
Single Run, Sweeps and Corners options: submitpointsenabled=0
